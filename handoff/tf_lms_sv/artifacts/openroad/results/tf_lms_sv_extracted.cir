* Extracted by KLayout on : 28/03/2026 12:21

.SUBCKT tf_lms_sv err[7] err[6] err[5] err[4] err[3] err[1] err[0] adapt_en VSS
+ VDD dxin[0] dxin[1] dxin[3] dxin[4] dxin[2] dxin[5] dxin[6] dxin[7] clock
+ yout[5] yout[0] yout[1] yout[7] yout[4] yout[6] yout[2] yout[3] err[2] xin[1]
+ xin[6] xin[4] xin[7] xin[0] xin[5] xin[2] reset xin[3]
X$2 \$33 VSS VDD err[7] BUF_X1
X$8 \$43 VSS VDD err[6] BUF_X1
X$14 \$153 VSS VDD err[5] BUF_X1
X$20 \$263 VSS VDD err[4] BUF_X1
X$26 \$584 VSS VDD err[3] BUF_X1
X$32 \$205 VSS VDD err[1] BUF_X1
X$38 \$19 VSS VDD err[0] BUF_X1
X$44 adapt_en VSS VDD \$21 BUF_X1
X$49 \$1339 VSS VDD \$I101714 INV_X2
X$51 \$1299 VSS VDD \$1301 CLKBUF_X1
X$52 \$1389 VSS VDD \$1383 CLKBUF_X1
X$53 \$1383 VSS VDD \$1299 CLKBUF_X1
X$54 VSS \$1339 \$I100532 \$1156 \$1381 \$1304 VDD DFFR_X1
X$55 \$1388 VSS VDD \$1391 CLKBUF_X1
X$56 \$1157 VSS VDD \$1267 CLKBUF_X1
X$57 \$1391 VSS VDD \$1515 CLKBUF_X1
X$58 \$1267 VSS VDD \$1388 CLKBUF_X1
X$65 \$964 \$1063 VSS VDD \$1315 XOR2_X1
X$73 \$1509 VSS VDD \$1381 CLKBUF_X1
X$74 VSS \$1339 \$I99815 \$1595 \$912 \$1304 VDD DFFR_X1
X$76 VSS \$1339 \$I99883 \$1648 \$1515 \$1304 VDD DFFR_X1
X$78 \$1520 VSS VDD \$1769 CLKBUF_X1
X$79 \$1651 VSS VDD \$1520 CLKBUF_X1
X$82 \$1770 VSS VDD \$1481 CLKBUF_X1
X$83 \$1523 VSS VDD \$1698 CLKBUF_X1
X$84 \$1481 VSS VDD \$1523 CLKBUF_X1
X$85 \$1522 VSS VDD \$1653 CLKBUF_X1
X$90 \$1598 VSS VDD \$1526 INV_X1
X$91 \$1526 \$1482 \$1483 VDD \$1097 VSS OAI21_X1
X$95 \$1533 VSS VDD \$1483 INV_X1
X$98 \$1403 \$1269 \$1598 VDD VSS \$1533 HA_X1
X$101 \$1538 VSS VDD \$1403 INV_X1
X$102 VSS \$1540 \$1538 \$1667 \$1158 \$1343 VDD FA_X1
X$104 VSS \$1406 \$1343 \$1544 \$1423 \$1270 VDD FA_X1
X$111 VSS \$1672 \$1540 \$1670 \$1066 \$1544 VDD FA_X1
X$114 \$1547 \$1548 \$1344 VDD VSS \$1676 HA_X1
X$115 \$293 \$428 VSS VDD \$1548 NOR2_X1
X$116 \$169 \$25 VSS VDD \$1547 NOR2_X1
X$118 \$1553 \$919 \$69 VDD VSS \$1485 HA_X1
X$121 \$1486 \$1707 VSS VDD \$919 NOR2_X1
X$123 \$1690 VSS VDD \$153 INV_X1
X$125 VSS \$1425 \$1329 \$1336 \$1347 \$1273 VDD FA_X1
X$126 \$1348 VSS VDD \$1711 CLKBUF_X1
X$129 \$362 VSS VDD \$1349 CLKBUF_X1
X$130 \$1436 VSS VDD \$1230 CLKBUF_X1
X$131 \$1274 VSS VDD \$1436 CLKBUF_X1
X$132 VSS \$589 \$I100451 \$2054 \$1351 \$45 VDD DFFR_X1
X$133 \$1069 VSS VDD \$1233 CLKBUF_X1
X$134 \$1449 VSS VDD \$1334 CLKBUF_X1
X$138 \$1486 \$33 VSS VDD \$1422 NAND2_X1
X$139 \$1161 \$1486 \$1422 VDD \$1553 VSS OAI21_X1
X$140 \$131 VSS VDD \$1488 CLKBUF_X1
X$141 VSS \$1688 \$1423 \$1686 \$925 \$2589 VDD FA_X1
X$143 \$1350 VSS VDD \$1684 CLKBUF_X1
X$144 \$1441 VSS VDD \$1489 CLKBUF_X1
X$145 \$1575 VSS VDD \$1351 CLKBUF_X1
X$146 \$1489 VSS VDD \$1575 CLKBUF_X1
X$148 \$386 VSS VDD \$1449 CLKBUF_X1
X$149 \$137 VSS VDD \$1681 CLKBUF_X1
X$152 \$1332 VSS VDD \$1454 CLKBUF_X1
X$154 \$1454 VSS VDD \$1352 CLKBUF_X1
X$155 \$1353 VSS VDD \$1457 CLKBUF_X1
X$156 \$1457 VSS VDD \$1331 CLKBUF_X1
X$159 \$1331 VSS VDD \$1581 CLKBUF_X1
X$160 VSS \$720 \$I100092 \$1607 \$1581 \$45 VDD DFFR_X1
X$162 \$1071 VSS VDD \$1354 CLKBUF_X1
X$165 VSS \$1281 \$1277 \$1880 \$1458 \$1461 VDD FA_X1
X$167 VSS \$1323 \$1461 \$1325 \$1279 \$1467 VDD FA_X1
X$171 \$1167 VSS VDD \$1458 INV_X1
X$174 \$1284 VSS VDD \$1459 INV_X1
X$176 \$1278 VSS VDD \$1490 INV_X1
X$177 \$1589 \$1490 VSS VDD \$1255 NAND2_X1
X$180 \$1589 VSS VDD \$1279 INV_X1
X$183 \$1469 VSS VDD \$1467 INV_X1
X$185 VSS \$1472 \$1253 \$1323 \$1468 \$1282 VDD FA_X1
X$187 \$727 \$1321 VSS VDD \$1472 NAND2_X1
X$191 VSS \$725 \$I100338 \$1363 \$1464 \$327 VDD DFFR_X1
X$192 \$1363 \$395 \$397 VSS VDD \$1172 NAND3_X1
X$193 \$1452 VSS VDD \$1464 CLKBUF_X1
X$195 \$1448 \$1173 VDD VSS \$1452 XNOR2_X1
X$199 \$1884 VSS VDD \$938 CLKBUF_X1
X$200 \$1847 VSS VDD \$1169 CLKBUF_X1
X$203 \$727 \$1494 VSS VDD \$1359 NAND2_X1
X$204 \$1579 VSS VDD \$1244 CLKBUF_X1
X$205 \$1359 VSS VDD \$1492 INV_X1
X$208 \$1171 \$1493 VSS VDD \$1468 NAND2_X1
X$211 \$1493 VSS VDD \$1494 INV_X1
X$212 \$1574 VSS VDD \$684 CLKBUF_X1
X$215 VSS \$725 \$I100017 \$1495 \$1566 \$327 VDD DFFR_X1
X$216 \$1495 \$395 \$397 VSS VDD \$1493 NAND3_X1
X$217 \$1495 \$1363 VSS VDD \$1568 NOR2_X1
X$222 \$1569 VSS VDD \$1448 CLKBUF_X1
X$223 \$1568 \$1496 VSS VDD \$1420 NAND2_X1
X$224 \$1367 \$1567 \$1366 VSS \$1569 VDD AOI21_X1
X$225 \$1367 \$1567 \$1368 VSS \$1447 VDD AOI21_X1
X$227 \$1617 VSS VDD \$1288 INV_X1
X$229 \$1567 VSS VDD \$1370 INV_X1
X$231 \$1368 \$1370 VDD VSS \$1566 XNOR2_X1
X$232 \$1369 \$1370 \$1288 VDD \$1216 VSS OAI21_X1
X$234 \$1370 \$1618 \$1177 VSS VDD \$1431 NOR3_X1
X$238 \$1832 \$1431 VSS VDD \$1289 NAND2_X1
X$239 \$1316 \$1431 \$1430 VSS \$1424 VDD AOI21_X1
X$240 \$1289 \$1624 \$1424 VDD \$215 VSS OAI21_X1
X$243 VSS \$464 \$I100163 \$1372 \$1417 \$327 VDD DFFR_X1
X$247 \$1561 \$1420 VSS VDD \$729 NOR2_X1
X$250 \$1659 \$1556 VSS VDD \$1561 NAND2_X1
X$251 VSS \$464 \$I100118 \$1499 \$1620 \$327 VDD DFFR_X1
X$252 \$1372 \$1499 VSS VDD \$1556 NOR2_X1
X$253 \$397 \$395 \$1372 VDD VSS \$1546 AND3_X1
X$254 \$1414 VSS VDD \$1417 CLKBUF_X1
X$258 \$397 \$395 \$1499 VDD VSS \$1657 AND3_X1
X$263 \$946 \$1373 VSS VDD \$1414 XOR2_X1
X$265 \$1374 \$1500 \$1084 VSS \$1624 VDD AOI21_X1
X$269 \$1179 VSS VDD \$1375 INV_X1
X$273 \$1396 \$1398 \$1085 VDD VSS \$1399 HA_X1
X$277 \$1632 VSS VDD \$1310 INV_X1
X$279 \$1633 VSS VDD \$1312 INV_X1
X$282 \$1500 VSS VDD \$1373 CLKBUF_X1
X$283 \$1542 \$1546 \$1500 VDD VSS \$1374 HA_X1
X$286 \$1535 VSS VDD \$1542 CLKBUF_X1
X$287 VSS \$464 \$I99807 \$1535 \$1530 \$327 VDD DFFR_X1
X$291 \$1504 \$1625 VDD VSS \$1530 XNOR2_X1
X$292 \$1629 \$1504 VSS VDD \$1503 NAND2_X1
X$294 \$1506 \$1294 \$1375 VSS \$1505 VDD AOI21_X1
X$295 \$1506 VSS VDD \$1507 INV_X1
X$296 \$1507 \$1295 VSS VDD \$1504 NAND2_X1
X$299 \$1519 \$1630 \$1294 VDD VSS \$1506 HA_X1
X$301 VSS \$1399 \$1519 \$1400 \$1645 \$1516 VDD FA_X1
X$302 VSS \$1376 \$1516 \$1396 \$1514 \$1512 VDD FA_X1
X$304 \$1513 VSS VDD \$1514 INV_X1
X$308 \$1394 VSS VDD \$1189 INV_X1
X$310 \$1384 VSS VDD \$1307 INV_X1
X$311 \$1377 \$1296 \$1387 VDD VSS \$1394 HA_X1
X$312 \$1746 \$1387 \$1181 VDD VSS \$1088 HA_X1
X$313 \$1378 \$1297 \$1379 VDD VSS \$1298 HA_X1
X$324 \$1510 \$1637 \$1180 VDD VSS \$1384 HA_X1
X$328 \$1379 \$1747 VSS VDD \$1508 NAND2_X1
X$350 \$4892 \$4896 \$5115 VDD VSS \$5304 HA_X1
X$351 \$4728 VSS VDD \$4071 CLKBUF_X1
X$352 \$5306 VSS VDD \$4890 CLKBUF_X1
X$353 \$5115 VSS VDD \$4984 INV_X1
X$355 \$4886 \$4731 \$5109 VDD VSS \$4883 HA_X1
X$356 \$5100 VSS VDD \$5101 CLKBUF_X1
X$357 \$4641 VSS VDD \$5552 INV_X1
X$358 \$5292 VSS VDD \$4877 CLKBUF_X1
X$361 VSS \$4075 \$I100157 \$5090 \$5094 \$4734 VDD DFFR_X1
X$366 \$5101 VSS VDD \$5116 CLKBUF_X1
X$367 \$4983 VSS VDD \$4895 CLKBUF_X1
X$368 VSS \$4984 \$5596 \$5302 \$4732 \$4729 VDD FA_X1
X$369 \$4074 \$5109 \$5303 VDD VSS \$5297 HA_X1
X$373 \$5090 VSS VDD \$5100 CLKBUF_X1
X$376 \$5288 VSS VDD \$5096 CLKBUF_X1
X$377 \$5286 VSS VDD \$4874 CLKBUF_X1
X$383 \$4738 \$5212 VDD VSS \$4988 XNOR2_X1
X$384 \$4988 \$5408 VDD VSS \$4538 XNOR2_X1
X$389 VSS \$5213 \$4735 \$4858 \$4738 \$5077 VDD FA_X1
X$391 VSS \$4992 \$5077 \$4991 \$4990 \$5214 VDD FA_X1
X$393 \$4736 VSS VDD \$4990 INV_X1
X$394 \$4991 VSS VDD \$4625 INV_X1
X$399 VSS \$4994 \$4850 \$4740 \$5059 \$4736 VDD FA_X1
X$406 \$4993 VSS VDD \$5516 INV_X1
X$407 \$4380 \$2609 VSS VDD \$4993 NAND2_X1
X$409 VSS \$4997 \$4838 \$4741 \$4609 \$4828 VDD FA_X1
X$411 \$4307 \$1743 VSS VDD \$4828 NAND2_X1
X$415 \$2606 \$1764 VSS VDD \$4997 NAND2_X1
X$418 \$4744 VSS VDD \$4546 INV_X1
X$423 VSS \$5052 \$4744 \$4747 \$5252 \$5217 VDD FA_X1
X$424 \$4746 VSS VDD \$5217 INV_X1
X$425 \$2371 \$2251 VSS VDD \$4746 NAND2_X1
X$426 \$4747 VSS VDD \$4181 INV_X1
X$431 \$5218 VSS VDD \$5052 INV_X1
X$432 \$4380 \$1904 VSS VDD \$5218 NAND2_X1
X$434 \$1902 \$4085 VSS VDD \$5252 NOR2_X1
X$437 VSS \$5000 \$I100132 \$5246 \$5423 \$3947 VDD DFFR_X1
X$438 VSS \$5000 \$I100352 \$2084 \$5032 \$3947 VDD DFFR_X1
X$440 \$5030 VSS VDD \$4582 CLKBUF_X1
X$441 \$4373 VSS VDD \$4361 CLKBUF_X1
X$444 \$5240 VSS VDD \$5002 CLKBUF_X1
X$445 \$5241 VSS VDD \$5240 CLKBUF_X1
X$446 \$5001 VSS VDD \$5219 CLKBUF_X1
X$447 \$5002 VSS VDD \$5001 CLKBUF_X1
X$448 \$5219 VSS VDD \$5032 CLKBUF_X1
X$450 \$4577 VSS VDD \$5026 CLKBUF_X1
X$451 \$5028 VSS VDD \$4780 CLKBUF_X1
X$452 \$5026 VSS VDD \$5028 CLKBUF_X1
X$454 VSS \$4552 \$I100477 \$5004 \$5220 \$3947 VDD DFFR_X1
X$455 \$5005 VSS VDD \$5006 CLKBUF_X1
X$456 \$4756 VSS VDD \$4758 CLKBUF_X1
X$457 \$4757 VSS VDD \$4756 CLKBUF_X1
X$458 \$4758 VSS VDD \$4772 CLKBUF_X1
X$459 \$4557 VSS VDD \$4759 CLKBUF_X1
X$460 \$4760 VSS VDD \$4762 CLKBUF_X1
X$470 \$4317 VSS VDD \$4097 CLKBUF_X1
X$475 \$5004 VSS VDD \$5005 CLKBUF_X1
X$476 \$5006 VSS VDD \$4757 CLKBUF_X1
X$488 \$3508 VSS VDD \$4344 CLKBUF_X1
X$489 \$4583 VSS VDD \$3908 CLKBUF_X1
X$492 \$4584 VSS VDD \$4249 CLKBUF_X1
X$493 \$4688 VSS VDD \$4251 CLKBUF_X1
X$495 \$1692 VSS VDD \$I98965 CLKBUF_X3
X$496 \$4252 VSS VDD \$4254 CLKBUF_X1
X$497 \$4360 VSS VDD \$4036 CLKBUF_X1
X$498 \$3909 VSS VDD \$4360 CLKBUF_X1
X$499 \$4364 VSS VDD \$4592 CLKBUF_X1
X$500 \$4592 VSS VDD \$4255 CLKBUF_X1
X$501 \$4256 VSS VDD \$4492 CLKBUF_X1
X$502 \$4257 VSS VDD \$4364 CLKBUF_X1
X$503 \$4157 VSS VDD \$4597 CLKBUF_X1
X$504 \$4367 VSS VDD \$4366 CLKBUF_X1
X$505 \$4597 VSS VDD \$4367 CLKBUF_X1
X$506 \$4370 VSS VDD \$4493 CLKBUF_X1
X$507 \$4601 VSS VDD \$4372 CLKBUF_X1
X$508 \$4494 VSS VDD \$3985 CLKBUF_X1
X$509 \$4377 VSS VDD \$4040 CLKBUF_X1
X$510 \$4041 VSS VDD \$4601 CLKBUF_X1
X$511 \$4042 VSS VDD \$4495 CLKBUF_X1
X$512 \$4383 VSS VDD \$4605 CLKBUF_X1
X$513 \$4605 VSS VDD \$4606 CLKBUF_X1
X$514 \$4606 VSS VDD \$4384 CLKBUF_X1
X$515 \$4260 VSS VDD \$I94706 CLKBUF_X1
X$516 \$4604 VSS VDD \$4382 CLKBUF_X1
X$517 VSS \$4260 \$I100223 \$4613 \$4262 \$3833 VDD DFFR_X1
X$518 VSS \$3628 \$I100515 \$4048 \$4617 \$3833 VDD DFFR_X1
X$519 VSS \$3628 \$I100482 \$4266 \$4412 \$3833 VDD DFFR_X1
X$520 VSS \$4506 \$4648 \$I87012 \$4416 \$3833 VDD DFFR_X1
X$521 VSS \$4510 \$I100242 \$4640 \$4268 \$3833 VDD DFFR_X1
X$522 VSS \$4510 \$4420 \$I87156 \$4269 \$3833 VDD DFFR_X1
X$523 \$4648 VSS VDD \$4422 CLKBUF_X1
X$536 VSS \$4480 \$I99915 \$4686 \$4765 \$3006 VDD DFFR_X1
X$537 \$4769 VSS VDD \$4323 CLKBUF_X1
X$539 VSS \$4480 \$I100151 \$4485 \$4245 \$3006 VDD DFFR_X1
X$541 \$4331 VSS VDD \$4484 CLKBUF_X1
X$542 \$4485 VSS VDD \$4330 CLKBUF_X1
X$543 \$4776 VSS VDD \$4562 CLKBUF_X1
X$544 \$4487 VSS VDD \$4776 CLKBUF_X1
X$546 VSS \$4480 \$I100401 \$4248 \$4562 \$3006 VDD DFFR_X1
X$547 \$4687 VSS VDD \$4782 CLKBUF_X1
X$548 \$4248 VSS VDD \$4573 CLKBUF_X1
X$549 VSS \$4944 \$I99926 \$4576 \$4782 \$1304 VDD DFFR_X1
X$550 \$4576 VSS VDD \$4578 CLKBUF_X1
X$551 \$4789 VSS VDD \$4790 CLKBUF_X1
X$554 \$4488 VSS VDD \$4490 CLKBUF_X1
X$555 \$4489 VSS VDD \$4488 CLKBUF_X1
X$556 \$4490 VSS VDD \$5037 CLKBUF_X1
X$557 \$5041 VSS VDD \$4795 CLKBUF_X1
X$559 \$5034 VSS VDD \$4491 CLKBUF_X1
X$560 VSS \$4944 \$I99925 \$4689 \$4491 \$1304 VDD DFFR_X1
X$561 \$2886 VSS VDD \$1692 CLKBUF_X3
X$565 \$4492 VSS VDD \$4257 CLKBUF_X1
X$568 \$3914 VSS VDD \$4037 CLKBUF_X1
X$571 \$4493 VSS VDD \$4494 CLKBUF_X1
X$572 \$4495 VSS VDD \$4497 CLKBUF_X1
X$573 VSS \$4260 \$I99868 \$4822 \$4497 \$3833 VDD DFFR_X1
X$574 \$4613 VSS VDD \$4045 CLKBUF_X1
X$575 \$4829 VSS VDD \$4044 CLKBUF_X1
X$576 \$4392 VSS VDD \$4400 CLKBUF_X1
X$577 \$4500 VSS VDD \$4501 CLKBUF_X1
X$578 \$4502 VSS VDD \$4697 CLKBUF_X1
X$579 \$4696 VSS VDD \$4837 CLKBUF_X1
X$581 \$4835 VSS VDD \$4846 CLKBUF_X1
X$582 \$191 VSS VDD \$3628 CLKBUF_X3
X$583 \$4834 VSS VDD \$4854 CLKBUF_X1
X$584 VSS \$3628 \$I99911 \$4052 \$4046 \$3833 VDD DFFR_X1
X$586 \$4857 VSS VDD \$5295 CLKBUF_X1
X$587 \$4856 VSS VDD \$4857 CLKBUF_X1
X$588 \$4861 VSS VDD \$4700 CLKBUF_X1
X$589 \$5298 VSS VDD \$4866 CLKBUF_X1
X$590 \$4866 VSS VDD \$4864 CLKBUF_X1
X$591 \$5099 VSS VDD \$4861 CLKBUF_X1
X$592 \$4855 VSS VDD \$4630 CLKBUF_X1
X$593 \$4265 VSS VDD \$4624 CLKBUF_X1
X$595 \$4507 VSS VDD \$4875 CLKBUF_X1
X$596 \$4870 VSS VDD \$4702 CLKBUF_X1
X$597 \$4508 VSS VDD \$4268 CLKBUF_X1
X$601 \$4878 VSS VDD \$4882 CLKBUF_X1
X$602 \$4640 VSS VDD \$4878 CLKBUF_X1
X$603 \$4647 VSS VDD \$4269 CLKBUF_X1
X$604 \$4882 VSS VDD \$4705 CLKBUF_X1
X$605 \$4706 VSS VDD \$4647 CLKBUF_X1
X$607 VSS \$4510 \$I99884 \$5192 \$33 \$45 VDD DFFR_X1
X$609 \$4025 VSS VDD \$5329 CLKBUF_X1
X$612 \$3923 VSS VDD \$4707 CLKBUF_X1
X$616 \$4271 \$4709 \$3165 VDD VSS \$3415 HA_X1
X$618 \$4057 \$4654 \$4513 \$4434 VSS VDD \$4432 NAND4_X1
X$620 \$5119 \$4894 \$4055 VDD VSS \$4710 HA_X1
X$621 \$3415 \$4055 VSS VDD \$4654 NAND2_X1
X$623 VSS \$33 \$20 \$4515 \$4901 VDD AOI21_X4
X$625 \$4432 \$4274 VDD VSS \$4665 XNOR2_X1
X$626 \$4515 \$4901 VSS VDD \$2052 NAND2_X1
X$628 \$4665 VSS VDD \$4671 CLKBUF_X1
X$633 \$4917 \$4712 \$4671 VSS \$4515 VDD NAND3_X4
X$635 \$4714 \$4677 VSS \$4712 VDD NAND2_X4
X$636 \$4674 VSS VDD \$5534 CLKBUF_X1
X$637 \$4223 VSS VDD \$4674 CLKBUF_X1
X$639 \$4059 VSS VDD \$4713 CLKBUF_X1
X$640 \$4449 \$4277 VSS VDD \$4677 NAND2_X2
X$645 \$4681 \$4277 \$4449 VSS \$4917 VDD NAND3_X4
X$646 \$4714 VSS VDD \$4681 INV_X1
X$649 \$4517 VSS VDD \$5554 CLKBUF_X1
X$652 \$4460 VSS VDD \$4680 CLKBUF_X1
X$654 \$4673 \$4282 VSS VDD \$4683 XOR2_X1
X$655 \$4468 \$4281 \$4669 VSS \$4673 VDD AOI21_X1
X$657 \$4683 VSS VDD \$4717 INV_X1
X$659 \$4669 \$4281 VDD VSS \$5348 XNOR2_X1
X$662 \$4468 \$4282 VSS VDD \$4518 NAND2_X1
X$663 \$4518 \$4519 \$4935 VSS VDD \$4974 NAND3_X1
X$664 \$4282 \$4281 \$4522 VSS VDD \$4935 NAND3_X1
X$665 \$4667 \$4283 \$4523 VDD VSS \$4524 HA_X1
X$670 \$4718 \$4719 VSS VDD \$4669 NAND2_X1
X$673 \$4524 VSS VDD \$4718 INV_X1
X$675 \$4241 VSS VDD \$5401 CLKBUF_X1
X$676 \$4284 VSS VDD \$4720 INV_X1
X$679 \$2442 VSS VDD \$5157 CLKBUF_X1
X$680 VSS \$4525 \$4527 \$1171 \$4915 \$327 VDD DFFR_X1
X$682 VSS \$4526 \$4238 \$4528 \$2560 \$4527 VDD FA_X1
X$683 VSS \$4285 \$4924 \$4529 \$4659 \$4467 VDD FA_X1
X$686 \$4924 VSS VDD \$5154 INV_X1
X$688 \$4652 VSS VDD \$4721 INV_X1
X$692 \$3607 VSS VDD \$5137 INV_X1
X$696 \$4914 \$4911 \$4530 VDD VSS \$4652 HA_X1
X$697 \$3180 \$1321 VSS VDD \$4912 NAND2_X1
X$698 \$940 \$3180 VDD VSS \$4914 AND2_X1
X$700 \$4287 \$1321 VSS VDD \$4532 NAND2_X1
X$702 \$4287 \$1494 VSS VDD \$4905 NAND2_X1
X$705 \$4289 VSS VDD \$4533 INV_X1
X$708 \$4532 VSS VDD \$4911 INV_X1
X$710 \$4912 VSS VDD \$4723 INV_X1
X$711 \$4905 VSS VDD \$4724 INV_X1
X$714 \$4533 \$4727 \$4725 VDD VSS \$4902 HA_X1
X$716 \$3180 \$1494 VSS VDD \$4898 NAND2_X1
X$717 \$4895 VSS VDD \$3589 CLKBUF_X1
X$718 \$4890 VSS VDD \$3997 CLKBUF_X1
X$719 \$4287 \$2184 VSS VDD \$4534 NAND2_X1
X$720 \$4294 VSS VDD \$4287 INV_X1
X$722 \$4898 VSS VDD \$4892 INV_X1
X$725 \$4534 VSS VDD \$4896 INV_X1
X$728 \$3180 \$2184 VSS VDD \$4535 NAND2_X1
X$729 \$4535 VSS VDD \$4886 INV_X1
X$730 \$4883 VSS VDD \$4729 INV_X1
X$731 \$4877 VSS VDD \$3936 CLKBUF_X1
X$732 \$4435 \$4436 \$4643 VDD VSS \$4536 HA_X1
X$735 \$4537 VSS VDD \$4431 CLKBUF_X1
X$741 \$4889 VSS VDD \$4731 INV_X1
X$743 \$4536 VSS VDD \$4732 INV_X1
X$745 \$4874 VSS VDD \$4537 CLKBUF_X1
X$749 \$5096 VSS VDD \$4638 CLKBUF_X1
X$755 \$4626 \$4868 VDD VSS \$4629 XNOR2_X1
X$756 \$4987 \$4867 VDD VSS \$4868 XNOR2_X1
X$758 \$4538 \$4629 VDD VSS \$4296 XNOR2_X1
X$760 \$4299 VSS VDD \$4297 INV_X1
X$762 VSS \$4623 \$4298 \$4079 \$4539 \$4300 VDD FA_X1
X$764 VSS \$4850 \$4623 \$4301 \$4625 \$4302 VDD FA_X1
X$767 VSS \$3038 \$4300 \$4302 \$3065 \$4413 VDD FA_X1
X$768 \$4740 VSS VDD \$4414 INV_X1
X$770 VSS \$4989 \$4867 \$4299 \$4627 \$4735 VDD FA_X1
X$773 \$4858 VSS VDD \$4539 INV_X1
X$774 \$4300 VSS VDD \$4627 INV_X1
X$776 \$4736 \$4300 VDD VSS \$4626 XNOR2_X1
X$778 \$4302 VSS VDD \$4738 INV_X1
X$782 \$4838 VSS VDD \$4303 INV_X1
X$784 \$4828 VSS VDD \$4542 INV_X1
X$785 \$4304 VSS VDD \$4839 INV_X1
X$787 \$4307 \$1764 VSS VDD \$4304 NAND2_X1
X$788 \$4609 VSS VDD \$4305 INV_X1
X$791 \$4307 \$1901 VSS VDD \$4609 NAND2_X1
X$795 VSS \$4595 \$4390 \$4309 \$4310 \$4308 VDD FA_X1
X$796 \$1735 \$4085 VSS VDD \$4310 NOR2_X1
X$799 \$3799 VSS VDD \$I69500 INV_X1
X$800 \$4582 VSS VDD \$4373 CLKBUF_X1
X$801 VSS \$4552 \$I100200 \$4580 \$4313 \$3947 VDD DFFR_X1
X$802 VSS \$4552 \$I100209 \$1901 \$4314 \$3947 VDD DFFR_X1
X$803 \$4098 VSS VDD \$4350 CLKBUF_X1
X$806 VSS \$4542 \$4413 \$4736 \$4305 \$4839 VDD FA_X1
X$808 VSS \$4546 \$4543 \$3805 \$4743 \$4741 VDD FA_X1
X$812 \$1904 \$2251 VSS VDD \$4548 NAND2_X1
X$813 \$4548 VSS VDD \$4308 INV_X1
X$814 \$4380 \$1902 VSS VDD \$4550 NAND2_X1
X$815 \$4550 VSS VDD \$4595 INV_X1
X$817 VSS \$5000 \$I100126 \$4810 \$5938 \$3947 VDD DFFR_X1
X$818 \$4810 VSS VDD \$4812 CLKBUF_X1
X$819 \$4812 VSS VDD \$5030 CLKBUF_X1
X$820 VSS \$4552 \$I99791 \$4779 \$5614 \$3947 VDD DFFR_X1
X$821 \$4580 VSS VDD \$4577 CLKBUF_X1
X$823 \$750 VSS VDD \$4552 CLKBUF_X3
X$824 \$4780 VSS VDD \$4345 CLKBUF_X1
X$825 \$4779 VSS VDD \$4315 CLKBUF_X1
X$826 VSS \$4552 \$I100108 \$4557 \$4772 \$3947 VDD DFFR_X1
X$827 \$4320 VSS VDD \$4319 CLKBUF_X1
X$828 \$4339 VSS VDD \$4102 CLKBUF_X1
X$830 VSS \$4552 \$I100402 \$1735 \$4558 \$3947 VDD DFFR_X1
X$839 \$4768 VSS VDD \$4761 CLKBUF_X1
X$840 \$4759 VSS VDD \$4760 CLKBUF_X1
X$841 \$4761 VSS VDD \$4558 CLKBUF_X1
X$842 \$4762 VSS VDD \$4768 CLKBUF_X1
X$855 \$2335 VSS VDD \$2725 CLKBUF_X1
X$856 \$2572 VSS VDD \$2770 CLKBUF_X1
X$857 \$2902 VSS VDD \$3045 CLKBUF_X1
X$858 \$2782 VSS VDD \$2781 CLKBUF_X1
X$859 \$2780 VSS VDD \$2902 CLKBUF_X1
X$860 VSS \$1593 \$I100218 \$2910 \$3152 \$1304 VDD DFFR_X1
X$861 \$2911 VSS VDD \$2727 CLKBUF_X1
X$863 \$2728 VSS VDD \$2729 CLKBUF_X1
X$864 \$2914 VSS VDD \$2913 CLKBUF_X1
X$865 \$3055 VSS VDD \$2914 CLKBUF_X1
X$867 \$2856 VSS VDD \$2730 CLKBUF_X1
X$868 \$2731 VSS VDD \$2856 CLKBUF_X1
X$869 \$2730 VSS VDD \$2492 CLKBUF_X1
X$870 VSS \$2862 \$I100330 \$2924 \$2860 \$1304 VDD DFFR_X1
X$871 \$2925 VSS VDD \$2801 CLKBUF_X1
X$872 \$3154 VSS VDD \$2800 CLKBUF_X1
X$873 \$3071 VSS VDD \$2931 CLKBUF_X1
X$875 \$2733 VSS VDD \$2863 CLKBUF_X1
X$876 \$2935 VSS VDD \$2733 CLKBUF_X1
X$877 \$2734 VSS VDD \$2933 CLKBUF_X1
X$878 \$2933 VSS VDD \$2935 CLKBUF_X1
X$879 \$2803 VSS VDD \$2641 CLKBUF_X1
X$891 \$2895 VSS VDD \$2898 CLKBUF_X1
X$892 \$3045 VSS VDD \$3151 CLKBUF_X1
X$893 \$3049 VSS VDD \$2911 CLKBUF_X1
X$894 \$2910 VSS VDD \$3049 CLKBUF_X1
X$895 \$2998 VSS VDD \$3052 CLKBUF_X1
X$896 VSS \$1593 \$I99841 \$3055 \$3052 \$1304 VDD DFFR_X1
X$898 \$3001 VSS VDD \$2860 CLKBUF_X1
X$899 \$2338 VSS VDD \$3001 CLKBUF_X1
X$900 \$2801 VSS VDD \$3002 CLKBUF_X1
X$901 \$2861 VSS VDD \$2925 CLKBUF_X1
X$902 \$3153 VSS VDD \$3062 CLKBUF_X1
X$903 \$2924 VSS VDD \$2861 CLKBUF_X1
X$904 VSS \$2862 \$I99843 \$3071 \$3062 \$1304 VDD DFFR_X1
X$905 VSS \$2862 \$I99847 \$3004 \$2863 \$3006 VDD DFFR_X1
X$906 VSS \$3074 \$I100067 \$3005 \$3076 \$3006 VDD DFFR_X1
X$907 \$2864 VSS VDD \$2735 CLKBUF_X1
X$911 \$2865 VSS VDD \$2736 CLKBUF_X1
X$915 VSS \$3074 \$I100016 \$3158 \$3081 \$3006 VDD DFFR_X1
X$917 \$2580 \$2579 VDD VSS \$3827 XNOR2_X1
X$919 \$2945 \$2647 \$2867 VSS \$2811 VDD AOI21_X1
X$920 \$2945 VSS VDD \$2740 INV_X1
X$921 \$2740 \$2868 VSS VDD \$2580 NAND2_X1
X$926 \$2134 VSS VDD \$2867 INV_X1
X$930 \$2949 \$2825 \$3008 VDD VSS \$2741 HA_X1
X$931 VSS \$2045 \$2823 \$2949 \$2953 \$2830 VDD FA_X1
X$935 \$2588 VSS VDD \$759 INV_X1
X$936 VSS \$2746 \$2953 \$3587 \$2415 \$2956 VDD FA_X1
X$940 \$2742 VSS VDD \$3391 INV_X1
X$943 \$3094 VSS VDD \$3009 INV_X1
X$946 \$3095 \$2743 \$3520 VDD VSS \$3094 HA_X1
X$949 VSS \$2313 \$2050 \$3010 \$3100 \$45 VDD DFFR_X1
X$950 \$3010 VSS VDD \$2536 INV_X1
X$951 \$2050 VSS VDD \$2834 CLKBUF_X1
X$959 \$3012 \$3165 VSS VDD \$2872 OR2_X1
X$962 \$2872 \$2965 VSS VDD \$1707 NAND2_X1
X$964 \$2975 VSS VDD \$2844 CLKBUF_X1
X$966 \$2979 VSS VDD \$2975 CLKBUF_X1
X$968 \$2981 VSS VDD \$2979 CLKBUF_X1
X$969 \$2313 VSS VDD \$I94592 CLKBUF_X1
X$970 \$191 VSS VDD \$2313 CLKBUF_X3
X$972 \$2210 VSS VDD \$3528 CLKBUF_X1
X$973 \$2854 VSS VDD \$2855 CLKBUF_X1
X$974 VSS \$2313 \$I100497 \$2713 \$3226 \$45 VDD DFFR_X1
X$975 VSS \$2347 \$I100462 \$3139 \$3138 \$45 VDD DFFR_X1
X$977 \$2348 VSS VDD \$2877 CLKBUF_X1
X$981 \$1874 VSS VDD \$3011 CLKBUF_X1
X$982 \$20 \$3111 \$3012 VSS \$3115 VDD AOI21_X1
X$983 \$3115 VSS VDD \$2965 CLKBUF_X1
X$986 \$3233 VSS VDD \$3121 CLKBUF_X1
X$987 VSS \$2313 \$I100109 \$3167 \$3014 \$45 VDD DFFR_X1
X$988 VSS \$2313 \$I100101 \$3441 \$3131 \$45 VDD DFFR_X1
X$989 VSS \$2313 \$I100080 \$3017 \$2750 \$45 VDD DFFR_X1
X$991 \$3139 VSS VDD \$3453 CLKBUF_X1
X$993 \$3144 VSS VDD \$3458 INV_X1
X$995 VSS \$2751 \$3144 \$3222 \$2015 \$3018 VDD FA_X1
X$996 VSS \$3019 \$3018 \$2850 \$2992 \$2994 VDD FA_X1
X$998 \$1719 VSS VDD \$2994 INV_X1
X$999 \$2879 \$458 VSS VDD \$2753 NAND2_X1
X$1000 VSS \$2984 \$2992 \$2755 \$2020 \$2840 VDD FA_X1
X$1001 \$1611 \$1321 VSS VDD \$2984 NAND2_X1
X$1002 \$2755 VSS VDD \$2836 INV_X1
X$1004 \$1718 VSS VDD \$3019 INV_X1
X$1007 \$3150 VSS VDD \$3467 CLKBUF_X1
X$1010 \$3216 VSS VDD \$3150 CLKBUF_X1
X$1013 \$2972 \$940 VSS VDD \$2840 NAND2_X1
X$1015 \$3022 VSS VDD \$2882 CLKBUF_X1
X$1017 \$3119 \$458 VSS VDD \$2560 NAND2_X1
X$1018 VSS \$2967 \$2835 \$3471 \$2758 \$2829 VDD FA_X1
X$1024 \$726 \$2359 VSS VDD \$3214 NAND2_X1
X$1026 \$1171 \$3030 VSS VDD \$3132 NAND2_X1
X$1029 \$2961 VSS VDD \$2706 CLKBUF_X1
X$1032 \$2959 VSS VDD \$2821 CLKBUF_X1
X$1035 \$2884 VSS VDD \$2885 CLKBUF_X1
X$1039 \$3210 VSS VDD \$2972 INV_X1
X$1040 \$1855 VSS VDD \$2961 CLKBUF_X1
X$1041 \$1130 VSS VDD \$2215 CLKBUF_X3
X$1042 \$3123 VSS VDD \$3491 CLKBUF_X1
X$1044 VSS \$2215 \$I99908 \$3123 \$3482 \$327 VDD DFFR_X1
X$1045 \$1130 VSS VDD \$I101758 INV_X4
X$1047 \$2886 VSS VDD \$1130 CLKBUF_X3
X$1049 \$2942 VSS VDD \$2817 CLKBUF_X1
X$1050 VSS \$1720 \$I100318 \$2942 \$2889 \$327 VDD DFFR_X1
X$1053 \$2926 VSS VDD \$2512 CLKBUF_X1
X$1054 \$2923 \$3032 \$2071 VDD VSS \$2503 HA_X1
X$1055 VSS \$1727 \$I100235 \$2808 \$2927 \$327 VDD DFFR_X1
X$1056 VSS \$1727 \$I100478 \$2926 \$3087 \$327 VDD DFFR_X1
X$1059 \$3108 VSS VDD \$3179 CLKBUF_X1
X$1060 \$3029 VSS VDD \$3119 INV_X1
X$1061 \$3030 \$3029 \$3291 VSS VDD \$3031 NOR3_X1
X$1062 \$2879 \$2759 VSS VDD \$3291 NAND2_X1
X$1064 \$3030 VSS VDD \$3032 INV_X1
X$1067 \$1720 VSS VDD \$I92597 CLKBUF_X1
X$1068 \$1130 VSS VDD \$1720 CLKBUF_X3
X$1069 \$3440 VSS VDD \$2813 CLKBUF_X1
X$1070 \$727 VSS VDD \$2692 CLKBUF_X1
X$1079 \$2921 \$3036 VDD VSS \$3087 XNOR2_X1
X$1080 \$2921 VSS VDD \$3037 INV_X1
X$1082 \$3080 \$2764 \$2603 VSS \$2921 VDD AOI21_X1
X$1083 \$2277 \$2764 VSS VDD \$2927 XOR2_X1
X$1088 \$3080 \$2764 \$2277 VSS \$3411 VDD AOI21_X1
X$1089 \$3077 \$3078 \$2764 VDD VSS \$3080 HA_X1
X$1092 \$3185 VSS VDD \$3077 INV_X1
X$1095 \$3200 VSS VDD \$2793 INV_X1
X$1098 \$2917 VSS VDD \$2648 INV_X1
X$1103 \$3075 VSS VDD \$3186 INV_X1
X$1106 VSS \$2765 \$3075 \$3070 \$3065 \$3038 VDD FA_X1
X$1107 \$3061 VSS VDD \$2369 INV_X1
X$1109 \$2609 \$1743 VSS VDD \$2894 NAND2_X1
X$1110 \$2894 VSS VDD \$2789 INV_X1
X$1113 \$3041 VSS VDD \$2778 INV_X1
X$1119 \$3070 VSS VDD \$3067 INV_X1
X$1121 VSS \$3059 \$2917 \$3061 \$3198 \$3298 VDD FA_X1
X$1123 \$3064 VSS VDD \$3040 INV_X1
X$1124 VSS \$3053 \$3059 \$3051 \$3195 \$3365 VDD FA_X1
X$1126 \$2907 \$3559 \$1928 VDD VSS \$2776 HA_X1
X$1142 \$1739 VSS VDD \$2092 CLKBUF_X1
X$1156 \$18416 VSS VDD \$18577 CLKBUF_X1
X$1158 \$18577 VSS VDD \$18576 CLKBUF_X1
X$1159 \$18576 VSS VDD \$18417 CLKBUF_X1
X$1161 \$18064 \$18493 VDD VSS \$18457 XNOR2_X1
X$1162 \$18493 VSS VDD \$18582 INV_X1
X$1163 \$18582 \$18064 \$18455 VDD \$18419 VSS OAI21_X1
X$1165 \$19051 VSS VDD \$17657 CLKBUF_X1
X$1170 \$18585 \$18617 \$18493 VDD VSS \$18420 HA_X1
X$1171 \$18420 VSS VDD \$18455 INV_X1
X$1173 VSS \$18589 \$18586 \$18288 \$18584 \$18421 VDD FA_X1
X$1175 \$18422 VSS VDD \$18589 INV_X1
X$1176 \$18494 VSS VDD \$18091 CLKBUF_X1
X$1177 VSS \$18386 \$18422 \$18382 \$18581 \$18423 VDD FA_X1
X$1179 \$18586 VSS VDD \$18585 INV_X1
X$1183 \$19166 VSS VDD \$17663 CLKBUF_X1
X$1184 \$18593 VSS VDD \$18584 INV_X1
X$1188 \$18699 VSS VDD \$18208 CLKBUF_X1
X$1189 \$18495 \$18597 \$18596 VDD VSS \$18619 HA_X1
X$1190 \$18594 VSS VDD \$18597 INV_X1
X$1193 \$18424 VSS VDD \$18425 INV_X1
X$1194 \$18426 VSS VDD \$18446 CLKBUF_X1
X$1195 \$16672 \$18628 VSS VDD \$18424 NAND2_X1
X$1199 \$16335 \$18628 VSS VDD \$18594 NAND2_X1
X$1202 \$18656 \$18562 \$18581 VDD VSS \$18654 HA_X1
X$1203 \$18429 VSS VDD \$18293 INV_X1
X$1205 \$15506 \$17559 VSS VDD \$18429 NAND2_X1
X$1208 \$18432 VSS VDD \$18500 INV_X1
X$1210 \$18260 \$16677 VSS VDD \$18432 NAND2_X1
X$1217 \$18624 \$16486 VSS VDD \$18499 NAND2_X1
X$1218 \$18499 VSS VDD \$18648 INV_X1
X$1219 \$18500 \$18648 \$18562 VDD VSS \$18626 HA_X1
X$1222 VSS \$18501 \$I100332 \$18503 \$18433 \$16907 VDD DFFR_X1
X$1225 \$18504 VSS VDD \$18436 INV_X1
X$1227 \$18436 \$18300 VSS VDD \$18628 NOR2_X2
X$1232 \$18095 \$18735 VDD VSS \$18502 XNOR2_X1
X$1233 \$18502 VSS VDD \$18433 CLKBUF_X1
X$1237 \$18100 VSS VDD \$18630 INV_X1
X$1238 \$18503 VSS VDD \$18504 CLKBUF_X1
X$1242 \$18506 \$18300 \$18708 VSS VDD NOR2_X4
X$1248 \$17411 VSS VDD \$18300 INV_X4
X$1252 \$18104 \$18304 \$18507 \$18437 VSS VDD \$18511 NAND4_X1
X$1272 \$18506 VSS VDD \$18520 INV_X1
X$1273 \$18520 \$18507 \$18437 VSS VDD \$18632 NAND3_X1
X$1275 \$18634 \$18511 \$18438 VDD VSS \$18508 OAI21_X2
X$1276 \$18508 VSS VDD \$18636 INV_X4
X$1296 \$17242 VSS VDD \$17115 CLKBUF_X1
X$1301 \$17295 VSS VDD \$16947 CLKBUF_X1
X$1303 \$17140 VSS VDD \$16862 CLKBUF_X1
X$1304 \$17142 VSS VDD \$17140 CLKBUF_X1
X$1305 VSS \$17372 \$I100190 \$17243 \$17299 \$12319 VDD DFFR_X1
X$1306 \$17304 VSS VDD \$17306 CLKBUF_X1
X$1307 \$17307 VSS VDD \$17304 CLKBUF_X1
X$1308 \$17306 VSS VDD \$17440 CLKBUF_X1
X$1309 \$17312 VSS VDD \$17311 CLKBUF_X1
X$1310 \$17311 VSS VDD \$17443 CLKBUF_X1
X$1311 \$13150 VSS VDD \$16461 CLKBUF_X3
X$1312 \$17378 VSS VDD \$17244 CLKBUF_X1
X$1313 \$17245 VSS VDD \$16653 CLKBUF_X1
X$1314 \$16866 VSS VDD \$17449 CLKBUF_X1
X$1315 \$17319 VSS VDD \$17052 CLKBUF_X1
X$1316 \$17321 VSS VDD \$17379 CLKBUF_X1
X$1317 \$17052 VSS VDD \$17324 CLKBUF_X1
X$1318 \$17323 VSS VDD \$17167 CLKBUF_X1
X$1319 \$17329 VSS VDD \$17321 CLKBUF_X1
X$1320 \$17460 VSS VDD \$16656 CLKBUF_X1
X$1321 \$17163 VSS VDD \$17323 CLKBUF_X1
X$1323 \$17333 VSS VDD \$17465 CLKBUF_X1
X$1324 \$17464 VSS VDD \$17333 CLKBUF_X1
X$1325 \$17054 VSS VDD \$17171 CLKBUF_X1
X$1326 VSS \$17247 \$17339 \$17350 \$17336 \$15672 VDD DFFR_X1
X$1327 \$17339 VSS VDD \$16469 INV_X1
X$1343 VSS \$17372 \$12525 \$17540 \$17371 \$15672 VDD DFFR_X1
X$1346 \$17541 VSS VDD \$17295 CLKBUF_X1
X$1347 \$17372 VSS VDD \$I101694 INV_X2
X$1348 \$17110 VSS VDD \$17372 CLKBUF_X3
X$1350 \$17301 VSS VDD \$17429 CLKBUF_X1
X$1351 \$17429 VSS VDD \$17299 CLKBUF_X1
X$1352 VSS \$17372 \$I100018 \$17591 \$16860 \$12319 VDD DFFR_X1
X$1354 \$17592 VSS VDD \$17597 CLKBUF_X1
X$1355 VSS \$17598 \$I100134 \$17720 \$17050 \$15672 VDD DFFR_X1
X$1357 \$17443 VSS VDD \$17378 CLKBUF_X1
X$1358 \$17244 VSS VDD \$17245 CLKBUF_X1
X$1359 \$17451 VSS VDD \$17156 CLKBUF_X1
X$1360 \$17440 VSS VDD \$17451 CLKBUF_X1
X$1362 \$17449 VSS VDD \$17319 CLKBUF_X1
X$1363 \$17110 VSS VDD \$I101750 INV_X4
X$1364 \$17324 VSS VDD \$17460 CLKBUF_X1
X$1365 \$17379 VSS VDD \$16868 CLKBUF_X1
X$1366 \$17167 VSS VDD \$17329 CLKBUF_X1
X$1369 \$17466 VSS VDD \$17472 CLKBUF_X1
X$1370 \$17055 VSS VDD \$17464 CLKBUF_X1
X$1371 \$17465 VSS VDD \$17466 CLKBUF_X1
X$1372 \$17056 VSS VDD \$16870 CLKBUF_X1
X$1373 \$17472 VSS VDD \$17474 CLKBUF_X1
X$1374 \$17474 VSS VDD \$17336 CLKBUF_X1
X$1376 \$16469 \$15168 VSS VDD \$18400 NAND2_X1
X$1379 \$15385 \$14852 VSS VDD \$17734 NAND2_X1
X$1383 \$17350 VSS VDD \$17486 CLKBUF_X1
X$1384 \$15168 \$15385 VDD VSS \$17060 AND2_X1
X$1393 \$17486 VSS VDD \$17627 CLKBUF_X1
X$1396 \$17350 \$13041 VSS VDD \$17384 NAND2_X1
X$1397 \$17384 VSS VDD \$17745 INV_X1
X$1398 \$16323 \$13098 VSS VDD \$17752 NAND2_X1
X$1400 \$17346 VSS VDD \$17186 CLKBUF_X1
X$1403 \$17248 VSS VDD \$17187 INV_X1
X$1404 \$17350 \$13178 VSS VDD \$17248 NAND2_X1
X$1409 \$16215 VSS VDD \$17386 CLKBUF_X1
X$1411 \$16877 VSS VDD \$17500 INV_X1
X$1413 VSS \$17353 \$17352 \$17197 \$17249 \$17194 VDD FA_X1
X$1417 \$17385 VSS VDD \$17065 INV_X1
X$1420 VSS \$17250 \$17823 \$17502 \$17636 \$17500 VDD FA_X1
X$1421 \$17352 VSS VDD \$17250 INV_X1
X$1424 \$17017 \$17066 \$17251 VDD VSS \$17355 HA_X1
X$1430 \$17502 VSS VDD \$17066 INV_X1
X$1431 \$17355 \$17251 \$17387 VSS \$18162 VDD AOI21_X1
X$1432 \$17387 \$17251 VDD VSS \$17758 XNOR2_X1
X$1435 \$17509 VSS VDD \$17508 CLKBUF_X1
X$1437 \$17358 VSS VDD \$17360 CLKBUF_X1
X$1438 \$17514 VSS VDD \$17358 CLKBUF_X1
X$1439 \$17360 VSS VDD \$17069 CLKBUF_X1
X$1440 \$17070 VSS VDD \$17363 CLKBUF_X1
X$1441 \$17363 VSS VDD \$17071 CLKBUF_X1
X$1442 \$17072 VSS VDD \$17032 CLKBUF_X1
X$1444 \$16666 VSS VDD \$17073 CLKBUF_X1
X$1445 \$17365 VSS VDD \$17041 CLKBUF_X3
X$1446 VSS \$17041 \$I100251 \$17390 \$17367 \$15181 VDD DFFR_X1
X$1447 \$17391 VSS VDD \$17369 CLKBUF_X1
X$1448 \$17369 VSS VDD \$17211 CLKBUF_X1
X$1450 \$17078 VSS VDD \$17079 CLKBUF_X1
X$1451 VSS \$16890 \$I100496 \$17255 \$17657 \$15181 VDD DFFR_X1
X$1453 \$17256 VSS VDD \$17229 CLKBUF_X1
X$1454 \$17359 VSS VDD \$17362 CLKBUF_X1
X$1455 \$17362 VSS VDD \$17233 CLKBUF_X1
X$1456 \$17257 VSS VDD \$17357 CLKBUF_X1
X$1457 \$17357 VSS VDD \$17232 CLKBUF_X1
X$1458 \$17229 VSS VDD \$17236 CLKBUF_X1
X$1461 \$17258 VSS VDD \$17234 INV_X1
X$1463 \$17798 VSS VDD \$15926 CLKBUF_X1
X$1465 \$17617 \$17616 \$17219 VDD VSS \$17261 HA_X1
X$1469 \$16343 \$17398 \$17263 VDD VSS \$17262 HA_X1
X$1470 \$17263 VSS VDD \$17205 CLKBUF_X1
X$1472 \$17401 \$17205 VDD VSS \$17265 XNOR2_X1
X$1473 \$17265 VSS VDD \$17202 CLKBUF_X1
X$1476 \$17263 \$17089 VSS VDD \$17348 NAND2_X1
X$1478 \$17267 VSS VDD \$17268 INV_X1
X$1479 \$17089 VSS VDD \$17487 CLKBUF_X1
X$1481 \$17175 VSS VDD \$17344 INV_X1
X$1482 \$17090 \$17268 \$17338 VSS VDD \$17270 NAND3_X1
X$1483 \$17089 \$16905 \$17179 VSS VDD \$17338 NAND3_X1
X$1486 \$17388 VSS VDD \$17509 CLKBUF_X1
X$1487 \$17508 VSS VDD \$17514 CLKBUF_X1
X$1491 \$17041 VSS VDD \$I92732 CLKBUF_X1
X$1493 \$17074 VSS VDD \$17075 CLKBUF_X1
X$1495 \$17209 VSS VDD \$17076 CLKBUF_X1
X$1498 \$17517 VSS VDD \$16330 CLKBUF_X1
X$1501 \$17520 VSS VDD \$17519 CLKBUF_X1
X$1502 \$17519 VSS VDD \$17391 CLKBUF_X1
X$1503 \$17390 VSS VDD \$17520 CLKBUF_X1
X$1506 \$17525 VSS VDD \$17524 CLKBUF_X1
X$1507 \$17524 VSS VDD \$17522 CLKBUF_X1
X$1508 \$17522 VSS VDD \$17082 CLKBUF_X1
X$1510 \$17531 VSS VDD \$17221 INV_X1
X$1511 \$17255 VSS VDD \$17084 CLKBUF_X1
X$1512 \$17083 VSS VDD \$17256 CLKBUF_X1
X$1513 \$17231 VSS VDD \$17359 CLKBUF_X1
X$1514 \$17239 \$17394 VDD VSS \$17531 XNOR2_X1
X$1519 VSS \$17535 \$17554 \$17258 \$17625 \$17622 VDD FA_X1
X$1522 \$17533 VSS VDD \$17535 INV_X1
X$1525 \$17556 \$17523 \$17227 VDD VSS \$17533 HA_X1
X$1528 \$17529 VSS VDD \$17622 INV_X1
X$1529 VSS \$18035 \$17529 \$17523 \$17086 \$17261 VDD FA_X1
X$1533 \$17611 \$17205 VSS VDD \$17396 NAND2_X1
X$1534 \$17396 \$17401 \$17397 VDD \$17562 VSS OAI21_X1
X$1535 \$17608 VSS VDD \$17397 INV_X1
X$1538 \$17262 VSS VDD \$17399 INV_X1
X$1542 \$17205 VSS VDD \$17402 INV_X1
X$1543 \$15560 VSS VDD \$16572 CLKBUF_X3
X$1544 \$17402 \$17404 \$17399 VDD \$17672 VSS OAI21_X1
X$1545 \$17267 \$17089 \$17602 VSS \$17404 VDD AOI21_X1
X$1546 \$17268 \$17402 \$17399 \$17348 \$17344 VDD VSS \$17565 OAI221_X1
X$1547 \$17485 \$17407 \$17344 VDD \$17602 VSS OAI21_X1
X$1549 \$17487 VSS VDD \$17567 INV_X1
X$1553 \$17408 \$16906 VSS VDD \$17485 NAND2_X1
X$1554 \$17270 \$17481 \$17463 VSS \$17401 VDD AOI21_X1
X$1555 \$17567 \$17092 \$17587 VSS VDD \$17481 NOR3_X1
X$1558 \$17170 \$17092 \$17093 VDD \$17175 VSS OAI21_X1
X$1559 \$17272 \$17094 \$17170 VDD \$17179 VSS OAI21_X1
X$1560 \$17569 VSS VDD \$17094 INV_X1
X$1561 \$17094 \$17584 \$17170 VDD \$17095 VSS OAI21_X1
X$1564 \$17096 \$17409 \$17408 VDD VSS \$17274 HA_X1
X$1565 \$17274 VSS VDD \$17170 INV_X1
X$1567 \$17331 VSS VDD \$17166 CLKBUF_X1
X$1568 \$17411 \$17099 VDD VSS \$16486 AND2_X1
X$1570 \$16791 VSS VDD \$17410 CLKBUF_X1
X$1575 \$17679 \$17315 \$17412 \$17099 VSS VDD \$17453 NOR4_X1
X$1576 \$17315 VSS VDD \$17318 CLKBUF_X1
X$1578 \$17101 VSS VDD \$17100 CLKBUF_X1
X$1579 \$17411 \$17318 VDD VSS \$17278 AND2_X1
X$1580 \$16157 VSS VDD \$17277 CLKBUF_X1
X$1581 VSS \$17275 \$17438 \$17279 \$16691 \$16907 VDD DFFR_X1
X$1587 VSS \$17275 \$I99897 \$17412 \$17439 \$16907 VDD DFFR_X1
X$1588 \$17413 \$17411 VSS VDD \$17575 NAND2_X1
X$1589 \$17412 VSS VDD \$17413 CLKBUF_X1
X$1590 \$17438 VSS VDD \$17435 CLKBUF_X1
X$1591 \$17435 VSS VDD \$17573 CLKBUF_X1
X$1592 \$16782 VSS VDD \$17578 INV_X1
X$1593 \$17575 VSS VDD \$17848 INV_X1
X$1595 \$17146 VSS VDD \$17310 INV_X1
X$1596 \$17125 \$17146 VDD VSS \$16398 XNOR2_X1
X$1598 \$17310 \$17125 \$17282 VDD \$16910 VSS OAI21_X1
X$1599 VSS \$17300 \$17145 \$17104 \$16694 \$17102 VDD FA_X1
X$1600 \$17104 VSS VDD \$17297 INV_X1
X$1602 \$17283 VSS VDD \$17300 INV_X1
X$1605 \$17293 VSS VDD \$17415 INV_X1
X$1609 \$17284 VSS VDD \$17292 INV_X1
X$1611 \$17285 \$17290 VDD VSS \$16332 XNOR2_X1
X$1612 \$17286 \$17290 \$17285 VSS \$17125 VDD AOI21_X1
X$1615 \$17288 \$16915 VSS VDD \$17285 NAND2_X1
X$1616 \$16916 VSS VDD \$17288 INV_X1
X$1627 \$17425 VSS VDD \$17282 INV_X1
X$1629 \$17426 \$17297 \$17146 VDD VSS \$17425 HA_X1
X$1634 \$17422 VSS VDD \$17426 INV_X1
X$1636 VSS \$17292 \$17422 \$17418 \$17415 \$17105 VDD FA_X1
X$1638 \$17418 VSS VDD \$17574 INV_X1
X$1641 \$17106 \$17574 \$17290 VDD VSS \$17286 HA_X1
X$1654 \$1596 VSS VDD \$1693 CLKBUF_X1
X$1655 \$1594 VSS VDD \$1865 CLKBUF_X1
X$1656 \$1756 VSS VDD \$1596 CLKBUF_X1
X$1657 \$1769 VSS VDD \$1694 CLKBUF_X1
X$1658 \$1648 VSS VDD \$1651 CLKBUF_X1
X$1659 \$1695 VSS VDD \$1762 CLKBUF_X1
X$1660 VSS \$1696 \$I100405 \$1697 \$1759 \$1304 VDD DFFR_X1
X$1662 \$1656 VSS VDD \$1597 CLKBUF_X1
X$1663 \$2116 VSS VDD \$1775 CLKBUF_X1
X$1664 \$1780 VSS VDD \$1656 CLKBUF_X1
X$1665 \$1782 VSS VDD \$1779 CLKBUF_X1
X$1669 \$1700 \$1598 VSS VDD \$1699 NAND2_X1
X$1670 \$1699 \$1483 \$1795 VSS VDD \$1701 NAND3_X1
X$1673 \$1599 \$1799 VSS VDD \$1662 NAND2_X1
X$1674 \$199 VSS VDD \$1800 INV_X1
X$1675 \$1800 \$1702 VSS VDD \$1799 NAND2_X1
X$1676 \$199 \$1602 \$1603 VSS VDD \$1599 NAND3_X1
X$1677 \$1602 \$1603 VSS VDD \$1702 NAND2_X1
X$1680 \$1485 VSS VDD \$1602 INV_X1
X$1683 VSS \$1271 \$1807 \$1704 \$1814 \$1676 VDD FA_X1
X$1685 \$718 \$759 VSS VDD \$1705 NOR2_X1
X$1686 \$1486 \$1706 VSS VDD \$266 NOR2_X1
X$1687 \$1829 VSS VDD \$1683 INV_X1
X$1690 VSS \$1709 \$1672 \$1829 \$1336 \$1686 VDD FA_X1
X$1692 \$1748 VSS VDD \$1911 CLKBUF_X1
X$1694 \$1639 VSS VDD \$1592 CLKBUF_X1
X$1695 \$1595 VSS VDD \$1639 CLKBUF_X1
X$1696 \$1753 VSS VDD \$1641 CLKBUF_X1
X$1697 \$1692 VSS VDD \$1339 CLKBUF_X3
X$1699 \$1593 VSS VDD \$I94388 CLKBUF_X1
X$1707 \$1592 VSS VDD \$1748 CLKBUF_X1
X$1711 \$1911 VSS VDD \$1753 CLKBUF_X1
X$1712 VSS \$1593 \$I99838 \$1756 \$1863 \$1304 VDD DFFR_X1
X$1714 \$1762 VSS VDD \$1759 CLKBUF_X1
X$1715 \$1694 VSS VDD \$1695 CLKBUF_X1
X$1716 \$2103 VSS VDD \$2105 CLKBUF_X1
X$1717 \$2249 VSS VDD \$1866 CLKBUF_X1
X$1718 \$1697 VSS VDD \$1522 CLKBUF_X1
X$1719 \$1653 VSS VDD \$1770 CLKBUF_X1
X$1720 \$1920 VSS VDD \$2113 CLKBUF_X1
X$1721 \$1779 VSS VDD \$2111 CLKBUF_X1
X$1722 VSS \$1696 \$I99830 \$2121 \$1698 \$1304 VDD DFFR_X1
X$1723 \$1934 VSS VDD \$1780 CLKBUF_X1
X$1724 \$1939 VSS VDD \$1782 CLKBUF_X1
X$1729 \$1482 \$1598 VDD VSS \$2577 XNOR2_X1
X$1730 \$1700 \$1869 \$2043 VSS \$1482 VDD AOI21_X1
X$1731 \$1701 VSS VDD \$1868 INV_X1
X$1733 \$1802 \$1948 \$1869 VDD VSS \$1700 HA_X1
X$1734 \$1667 VSS VDD \$1948 INV_X1
X$1739 \$1950 VSS VDD \$1802 INV_X1
X$1742 VSS \$1806 \$1950 \$2137 \$1670 \$1870 VDD FA_X1
X$1744 \$1807 VSS VDD \$1870 INV_X1
X$1746 \$1954 VSS VDD \$1806 INV_X1
X$1748 VSS \$1964 \$1954 \$1962 \$1683 \$1704 VDD FA_X1
X$1751 VSS \$1821 \$1814 \$1871 \$1967 \$1705 VDD FA_X1
X$1752 \$1009 \$1706 VSS VDD \$1821 NOR2_X1
X$1757 \$1710 VSS VDD \$1709 INV_X1
X$1759 \$1984 VSS VDD \$1486 INV_X1
X$1760 \$1711 VSS VDD \$1874 CLKBUF_X1
X$1762 \$1706 \$718 VSS VDD \$1688 OR2_X1
X$1767 \$1684 VSS VDD \$1715 CLKBUF_X1
X$1772 \$584 VSS VDD \$1706 INV_X1
X$1775 \$1715 VSS VDD \$1875 CLKBUF_X1
X$1778 \$1352 VSS VDD \$1353 CLKBUF_X1
X$1781 \$1354 VSS VDD \$1606 CLKBUF_X1
X$1783 \$1846 VSS VDD \$1849 CLKBUF_X1
X$1784 \$1849 VSS VDD \$1608 CLKBUF_X1
X$1785 \$1717 VSS VDD \$1609 CLKBUF_X1
X$1786 \$1607 VSS VDD \$1717 CLKBUF_X1
X$1790 VSS \$720 \$I100141 \$2348 \$2000 \$45 VDD DFFR_X1
X$1792 \$1878 \$2007 VDD VSS \$837 XNOR2_X1
X$1793 \$2010 VSS VDD \$1879 INV_X1
X$1796 VSS \$1719 \$1278 \$1167 \$1718 \$1674 VDD FA_X1
X$1798 VSS \$1860 \$1674 \$1589 \$1859 \$1610 VDD FA_X1
X$1799 \$1853 VSS VDD \$1610 INV_X1
X$1800 \$1855 \$458 VSS VDD \$1852 NAND2_X1
X$1801 \$1611 \$458 VSS VDD \$1853 NAND2_X1
X$1804 VSS \$1719 \$2010 \$2176 \$1718 \$1882 VDD FA_X1
X$1805 \$2019 VSS VDD \$1882 INV_X1
X$1807 \$1852 VSS VDD \$1859 INV_X1
X$1808 \$2020 VSS VDD \$1860 INV_X1
X$1809 VSS \$1852 \$2019 \$1883 \$2028 \$2020 VDD FA_X1
X$1811 VSS \$1492 \$1469 \$2030 \$1844 \$1666 VDD FA_X1
X$1813 \$726 \$1321 VSS VDD \$1842 NAND2_X1
X$1815 \$1842 VSS VDD \$1666 INV_X1
X$1818 \$2008 \$1494 \$1567 VDD VSS \$1617 HA_X1
X$1819 \$1617 VSS VDD \$1367 CLKBUF_X1
X$1823 \$2027 VSS VDD \$1847 CLKBUF_X1
X$1824 \$2030 VSS VDD \$2034 INV_X1
X$1826 \$2025 VSS VDD \$2027 CLKBUF_X1
X$1830 VSS \$1720 \$I99898 \$1889 \$2016 \$327 VDD DFFR_X1
X$1831 \$1721 VSS VDD \$1838 INV_X1
X$1832 \$1618 \$1838 \$1369 VDD \$1366 VSS OAI21_X1
X$1835 \$1621 VSS VDD \$1620 CLKBUF_X1
X$1836 \$1624 \$1622 VDD VSS \$1621 XNOR2_X1
X$1840 \$1725 VSS VDD \$1622 CLKBUF_X1
X$1843 \$1825 \$1657 \$1725 VDD VSS \$1987 HA_X1
X$1846 \$1721 \$2011 VDD VSS \$2064 XNOR2_X1
X$1850 \$1994 \$1892 \$2161 \$1893 \$1724 VDD VSS \$1430 OAI221_X1
X$1851 \$1893 \$1723 VSS VDD \$1832 NOR2_X1
X$1858 \$1723 \$1624 \$1724 VDD \$2156 VSS OAI21_X1
X$1860 \$1725 \$2224 VSS VDD \$1723 NAND2_X1
X$1863 \$1725 \$1500 VSS VDD \$1894 NAND2_X1
X$1866 \$1622 VSS VDD \$1897 INV_X1
X$1867 \$1374 VSS VDD \$1896 INV_X1
X$1868 \$1374 \$1500 \$946 VSS \$2075 VDD AOI21_X1
X$1870 \$1987 VSS VDD \$2073 INV_X1
X$1873 VSS \$1727 \$I100217 \$1974 \$1824 \$327 VDD DFFR_X1
X$1878 \$1974 VSS VDD \$1825 CLKBUF_X1
X$1880 \$1625 \$1505 \$1626 VDD \$1728 VSS OAI21_X1
X$1881 \$1728 \$2078 VSS VDD \$1824 XOR2_X1
X$1882 \$1626 \$1503 VSS VDD \$2229 NAND2_X1
X$1884 \$1730 \$1628 VSS VDD \$1816 NAND2_X1
X$1885 \$1730 \$1629 \$1294 \$1375 VSS VDD \$1968 NAND4_X1
X$1886 \$1629 VSS VDD \$1625 INV_X1
X$1887 \$1507 \$1625 \$1626 VDD \$1628 VSS OAI21_X1
X$1891 \$1960 \$1957 \$1629 VDD VSS \$1732 HA_X1
X$1892 \$1732 VSS VDD \$1626 INV_X1
X$1897 \$1787 VSS VDD \$1630 INV_X1
X$1899 \$1786 VSS VDD \$1733 INV_X1
X$1902 \$1959 VSS VDD \$1960 INV_X1
X$1903 VSS \$1733 \$1959 \$1787 \$1956 \$1898 VDD FA_X1
X$1904 \$1953 VSS VDD \$1898 INV_X1
X$1906 VSS \$1772 \$1786 \$1645 \$1928 \$1631 VDD FA_X1
X$1908 \$1735 \$1764 VSS VDD \$1736 NAND2_X1
X$1909 \$1736 VSS VDD \$1774 INV_X1
X$1910 \$1737 \$1937 \$1398 VDD VSS \$1772 HA_X1
X$1913 VSS \$1740 \$1513 \$1632 \$1758 \$1642 VDD FA_X1
X$1915 \$1742 \$1634 \$1633 VDD VSS \$1512 HA_X1
X$1917 \$1755 VSS VDD \$1510 INV_X1
X$1919 \$1916 VSS VDD \$1377 INV_X1
X$1920 \$1635 VSS VDD \$1637 INV_X1
X$1933 VSS \$1734 \$1953 \$1631 \$1785 \$1899 VDD FA_X1
X$1935 VSS \$1738 \$1785 \$1737 \$1774 \$1900 VDD FA_X1
X$1936 \$1932 VSS VDD \$1738 INV_X1
X$1937 \$1902 \$1743 VSS VDD \$1932 NAND2_X1
X$1940 \$1901 \$1902 VSS VDD \$1642 NAND2_X1
X$1941 \$1764 \$1739 VSS VDD \$1758 NAND2_X1
X$1942 \$1743 \$1735 VSS VDD \$1740 NAND2_X1
X$1944 \$1921 VSS VDD \$1742 INV_X1
X$1945 \$1903 VSS VDD \$1634 INV_X1
X$1948 \$1743 \$1739 VSS VDD \$1755 NAND2_X1
X$1949 \$1905 VSS VDD \$1296 INV_X1
X$1951 \$1901 \$1735 VSS VDD \$1635 NAND2_X1
X$1953 \$1745 \$1907 \$1910 VDD VSS \$1746 HA_X1
X$1954 \$1909 \$1910 \$2091 VDD VSS \$1747 HA_X1
X$1968 \$5719 VSS VDD \$5789 CLKBUF_X1
X$1969 \$5788 VSS VDD \$5718 CLKBUF_X1
X$1970 \$5896 VSS VDD \$5898 CLKBUF_X1
X$1971 \$5720 VSS VDD \$6160 CLKBUF_X1
X$1972 \$6405 VSS VDD \$5717 CLKBUF_X1
X$1973 \$5804 VSS VDD \$5802 CLKBUF_X1
X$1974 VSS \$5715 \$I100291 \$6165 \$5568 \$3006 VDD DFFR_X1
X$1975 \$5722 VSS VDD \$5721 CLKBUF_X1
X$1976 \$5723 VSS VDD \$5804 CLKBUF_X1
X$1980 VSS \$4480 \$I100414 \$5613 \$6135 \$3006 VDD DFFR_X1
X$1983 \$5567 VSS VDD \$6136 CLKBUF_X1
X$1984 \$6136 VSS VDD \$5894 CLKBUF_X1
X$1985 VSS \$4480 \$I99863 \$5719 \$6139 \$3006 VDD DFFR_X1
X$1986 \$6151 VSS VDD \$5896 CLKBUF_X1
X$1987 VSS \$5715 \$I99848 \$6164 \$5898 \$3006 VDD DFFR_X1
X$1988 \$5569 VSS VDD \$5720 CLKBUF_X1
X$1989 \$6160 VSS VDD \$5797 CLKBUF_X1
X$1991 \$5721 VSS VDD \$6063 CLKBUF_X1
X$1992 \$6165 VSS VDD \$5722 CLKBUF_X1
X$1994 \$5173 VSS VDD \$5962 CLKBUF_X1
X$1997 \$5571 VSS VDD \$5243 CLKBUF_X1
X$1998 \$5899 VSS VDD \$5570 CLKBUF_X1
X$1999 \$5248 VSS VDD \$6170 CLKBUF_X1
X$2000 \$5970 VSS VDD \$5972 CLKBUF_X1
X$2001 \$5572 VSS VDD \$5365 CLKBUF_X1
X$2002 VSS \$5366 \$I100367 \$5900 \$5725 \$3006 VDD DFFR_X1
X$2003 VSS \$5366 \$I100369 \$5902 \$5901 \$3006 VDD DFFR_X1
X$2004 VSS \$4954 \$I100244 \$5728 \$5989 \$3006 VDD DFFR_X1
X$2005 VSS \$4954 \$I100358 \$6198 \$5731 \$3006 VDD DFFR_X1
X$2006 VSS \$4954 \$I100430 \$5821 \$5732 \$3006 VDD DFFR_X1
X$2007 \$5821 VSS VDD \$6004 CLKBUF_X1
X$2008 \$5734 VSS VDD \$6002 CLKBUF_X1
X$2011 \$5175 VSS VDD \$5971 CLKBUF_X1
X$2012 \$6065 VSS VDD \$5725 CLKBUF_X1
X$2013 \$5972 VSS VDD \$6065 CLKBUF_X1
X$2014 \$5811 VSS VDD \$5970 CLKBUF_X1
X$2015 \$6173 VSS VDD \$6178 CLKBUF_X1
X$2016 \$5900 VSS VDD \$6173 CLKBUF_X1
X$2017 \$6178 VSS VDD \$6176 CLKBUF_X1
X$2018 \$6066 VSS VDD \$6182 CLKBUF_X1
X$2019 \$6182 VSS VDD \$5901 CLKBUF_X1
X$2022 \$6067 VSS VDD \$6069 CLKBUF_X1
X$2023 \$5902 VSS VDD \$6067 CLKBUF_X1
X$2024 \$6069 VSS VDD \$6070 CLKBUF_X1
X$2025 \$6071 VSS VDD \$6184 CLKBUF_X1
X$2026 \$6184 VSS VDD \$5989 CLKBUF_X1
X$2028 \$5992 VSS VDD \$6186 CLKBUF_X1
X$2029 \$5728 VSS VDD \$6072 CLKBUF_X1
X$2030 \$4954 VSS VDD \$I92631 CLKBUF_X1
X$2031 \$6189 VSS VDD \$5992 CLKBUF_X1
X$2032 \$6186 VSS VDD \$6194 CLKBUF_X1
X$2033 \$6194 VSS VDD \$5731 CLKBUF_X1
X$2035 \$6193 VSS VDD \$5996 CLKBUF_X1
X$2036 \$6198 VSS VDD \$6073 CLKBUF_X1
X$2037 \$6195 VSS VDD \$5732 CLKBUF_X1
X$2038 \$6074 VSS VDD \$6193 CLKBUF_X1
X$2039 \$5996 VSS VDD \$6195 CLKBUF_X1
X$2041 VSS \$4954 \$I99844 \$6076 \$3516 \$3833 VDD DFFR_X1
X$2042 \$5826 VSS VDD \$5828 CLKBUF_X1
X$2043 \$5822 VSS VDD \$5482 CLKBUF_X1
X$2044 \$5828 VSS VDD \$5667 CLKBUF_X1
X$2045 \$5830 VSS VDD \$5904 CLKBUF_X1
X$2046 \$5905 VSS VDD \$5834 CLKBUF_X1
X$2047 VSS \$5735 \$I100517 \$6014 \$5834 \$3833 VDD DFFR_X1
X$2048 VSS \$5735 \$I100185 \$5736 \$5840 \$3833 VDD DFFR_X1
X$2049 VSS \$4506 \$I100240 \$5739 \$5850 \$3833 VDD DFFR_X1
X$2050 VSS \$4506 \$I100410 \$6041 \$5742 \$3833 VDD DFFR_X1
X$2052 \$6042 VSS VDD \$6039 CLKBUF_X1
X$2053 VSS \$5744 \$5865 \$I87256 \$5859 \$45 VDD DFFR_X1
X$2056 \$5374 VSS VDD \$4698 CLKBUF_X1
X$2057 \$4505 VSS VDD \$6077 CLKBUF_X1
X$2058 \$5904 VSS VDD \$5905 CLKBUF_X1
X$2059 \$5375 VSS VDD \$5670 CLKBUF_X1
X$2060 \$5578 VSS VDD \$6010 CLKBUF_X1
X$2061 \$6014 VSS VDD \$6016 CLKBUF_X1
X$2062 \$5493 VSS VDD \$5735 CLKBUF_X3
X$2064 VSS \$5735 \$I99951 \$6520 \$5907 \$3833 VDD DFFR_X1
X$2065 VSS \$4506 \$I99876 \$6233 \$6471 \$3833 VDD DFFR_X1
X$2067 \$6236 VSS VDD \$6235 CLKBUF_X1
X$2068 \$6234 VSS VDD \$6241 CLKBUF_X1
X$2069 \$6041 VSS VDD \$6242 CLKBUF_X1
X$2070 \$6242 VSS VDD \$6042 CLKBUF_X1
X$2071 \$5326 VSS VDD \$6748 CLKBUF_X1
X$2072 \$6039 VSS VDD \$6266 CLKBUF_X1
X$2073 \$6085 VSS VDD \$6250 CLKBUF_X1
X$2074 \$6086 VSS VDD \$6255 CLKBUF_X1
X$2075 \$6258 VSS VDD \$6257 CLKBUF_X1
X$2076 \$5910 VSS VDD \$6088 CLKBUF_X1
X$2078 \$6266 VSS VDD \$6264 CLKBUF_X1
X$2079 \$6051 VSS VDD \$5859 CLKBUF_X1
X$2080 \$6264 VSS VDD \$6051 CLKBUF_X1
X$2082 \$5700 \$5356 VSS VDD \$6268 NOR2_X1
X$2083 \$4021 VSS VDD \$6356 CLKBUF_X1
X$2085 \$4216 VSS VDD \$6493 CLKBUF_X1
X$2086 \$5745 VSS VDD \$4272 INV_X1
X$2087 \$5865 VSS VDD \$5746 CLKBUF_X1
X$2089 \$5700 \$5745 VSS VDD \$5908 NOR2_X1
X$2090 \$45 VSS VDD \$5700 INV_X1
X$2093 \$5584 VSS VDD \$5872 CLKBUF_X1
X$2095 VSS \$6047 \$5196 \$4442 \$5875 \$5872 VDD FA_X1
X$2097 \$4275 VSS VDD \$7183 CLKBUF_X1
X$2100 \$5748 VSS VDD \$5878 CLKBUF_X1
X$2103 \$5750 \$5749 VDD VSS \$5745 XNOR2_X1
X$2104 \$5751 \$5749 \$5750 VSS \$5586 VDD AOI21_X1
X$2105 \$5587 \$5913 \$5200 VSS VDD \$5706 NOR3_X1
X$2106 \$5749 VSS VDD \$5913 INV_X1
X$2108 \$5751 VSS VDD \$5889 INV_X1
X$2110 \$5752 \$5753 \$5749 VDD VSS \$5751 HA_X1
X$2112 \$5753 \$5752 \$5916 VDD VSS \$I97355 HA_X1
X$2114 \$5873 VSS VDD \$5752 INV_X1
X$2120 \$5390 VSS VDD \$6092 INV_X1
X$2121 \$6281 \$6092 \$5585 VDD \$6053 VSS OAI21_X1
X$2122 \$6281 VSS VDD \$6047 INV_X1
X$2126 \$5397 VSS VDD \$6534 CLKBUF_X1
X$2127 \$5915 \$5913 \$5889 \$6035 \$6093 VDD VSS \$5396 OAI221_X1
X$2129 \$6294 \$5915 \$6095 VSS VDD \$5750 NAND3_X1
X$2130 \$6299 \$6094 VSS VDD \$6294 NAND2_X1
X$2131 \$5398 VSS VDD \$6921 CLKBUF_X1
X$2132 \$6094 \$5916 VSS VDD \$6035 NAND2_X1
X$2135 \$5590 VSS VDD \$6099 CLKBUF_X1
X$2139 \$6309 VSS VDD \$5915 INV_X1
X$2142 \$5155 \$6028 VSS VDD \$5680 NAND2_X1
X$2145 \$5917 \$5754 VSS VDD \$5679 NAND2_X1
X$2146 \$5858 \$5862 \$6105 VDD VSS \$5863 HA_X1
X$2147 \$5863 VSS VDD \$5917 INV_X1
X$2149 \$5591 VSS VDD \$5858 INV_X1
X$2152 \$5755 VSS VDD \$5920 INV_X1
X$2155 \$6103 \$6105 VDD VSS \$6102 XNOR2_X1
X$2156 \$6105 \$6103 VSS VDD \$5754 NAND2_X1
X$2159 \$6104 \$5917 \$6023 VSS VDD \$6028 NAND3_X1
X$2160 \$5918 \$6105 VSS VDD \$6104 NAND2_X1
X$2162 \$6107 \$5918 VSS VDD \$6103 OR2_X1
X$2164 \$5919 \$6105 \$6321 VSS VDD \$6023 NAND3_X1
X$2165 \$6013 \$5920 \$5919 VDD VSS \$5918 HA_X1
X$2166 \$6105 \$5919 \$6108 \$5757 VDD VSS \$6018 AND4_X1
X$2168 \$5756 \$5758 \$5155 \$6018 VSS VDD \$5857 NAND4_X1
X$2170 \$5757 \$5758 \$5756 VSS VDD \$5923 NAND3_X1
X$2174 \$5922 \$6110 \$6112 VDD \$6321 VSS OAI21_X1
X$2175 \$5922 \$5923 VSS VDD \$6111 NAND2_X1
X$2176 \$6292 VSS VDD \$6112 INV_X1
X$2179 \$5924 \$6310 \$6108 VDD VSS \$6292 HA_X1
X$2180 VSS \$5842 \$5924 \$5845 \$5851 \$5844 VDD FA_X1
X$2181 \$5848 VSS VDD \$6310 INV_X1
X$2182 \$5847 \$5845 \$5757 VDD VSS \$6008 HA_X1
X$2186 \$6008 VSS VDD \$5922 INV_X1
X$2190 VSS \$5557 \$5847 \$5758 \$5759 \$5297 VDD FA_X1
X$2191 VSS \$4075 \$I100259 \$5926 \$5837 \$4734 VDD DFFR_X1
X$2192 \$6001 VSS VDD \$6000 CLKBUF_X1
X$2194 \$1130 VSS VDD \$4075 CLKBUF_X3
X$2195 VSS \$4075 \$I100437 \$5763 \$5762 \$4734 VDD DFFR_X1
X$2198 \$6113 VSS VDD \$5595 CLKBUF_X1
X$2201 \$6114 VSS VDD \$5925 CLKBUF_X1
X$2205 \$6275 VSS VDD \$5999 CLKBUF_X1
X$2206 \$6000 VSS VDD \$6275 CLKBUF_X1
X$2207 \$5926 VSS VDD \$6001 CLKBUF_X1
X$2208 \$6272 VSS VDD \$6262 CLKBUF_X1
X$2209 \$5927 VSS VDD \$5928 CLKBUF_X1
X$2210 \$5999 VSS VDD \$5549 CLKBUF_X1
X$2211 \$6262 VSS VDD \$5652 CLKBUF_X1
X$2214 \$5931 VSS VDD \$5932 CLKBUF_X1
X$2217 \$5764 VSS VDD \$5409 INV_X1
X$2220 \$5995 \$5764 VDD VSS \$5408 XNOR2_X1
X$2222 \$5817 \$5640 \$5764 VDD VSS \$5995 HA_X1
X$2223 VSS \$5766 \$5643 \$5520 \$5933 \$5768 VDD FA_X1
X$2224 \$4307 \$4085 \$5768 VDD \$5817 VSS OAI21_X1
X$2225 \$5813 VSS VDD \$5814 INV_X1
X$2226 \$2606 \$4380 VSS VDD \$5813 NAND2_X1
X$2228 \$4307 \$4380 VSS VDD \$5768 NAND2_X1
X$2233 \$5772 VSS VDD \$5987 CLKBUF_X1
X$2236 VSS \$3799 \$4551 \$5808 \$5984 \$4734 VDD DFFR_X1
X$2237 \$5808 VSS VDD \$4085 INV_X1
X$2239 \$5979 VSS VDD \$5775 CLKBUF_X1
X$2240 VSS \$5000 \$I100378 \$5939 \$5976 \$3947 VDD DFFR_X1
X$2241 \$5941 VSS VDD \$5601 CLKBUF_X1
X$2242 VSS \$5426 \$I100416 \$5959 \$6131 \$3947 VDD DFFR_X1
X$2243 VSS \$5426 \$I100428 \$5944 \$5956 \$3947 VDD DFFR_X1
X$2244 \$5779 VSS VDD \$5791 CLKBUF_X1
X$2245 \$5945 VSS VDD \$5780 CLKBUF_X1
X$2246 \$5781 VSS VDD \$5947 CLKBUF_X1
X$2247 \$5948 VSS VDD \$5781 CLKBUF_X1
X$2248 \$5221 VSS VDD \$5782 CLKBUF_X1
X$2249 \$5783 VSS VDD \$5429 CLKBUF_X1
X$2264 \$5933 VSS VDD \$5640 INV_X1
X$2266 \$4307 \$2251 VSS VDD \$5933 NAND2_X1
X$2269 VSS \$5988 \$I100014 \$2609 \$6432 \$4734 VDD DFFR_X1
X$2272 VSS \$5988 \$I99950 \$6122 \$5935 \$6120 VDD DFFR_X1
X$2273 VSS \$5988 \$I100102 \$6215 \$5936 \$6120 VDD DFFR_X1
X$2274 \$6203 VSS VDD \$6126 CLKBUF_X1
X$2275 \$6124 VSS VDD \$6209 CLKBUF_X1
X$2276 \$6126 VSS VDD \$5984 CLKBUF_X1
X$2277 \$6192 VSS VDD \$6203 CLKBUF_X1
X$2279 \$6127 VSS VDD \$6181 CLKBUF_X1
X$2280 \$6181 VSS VDD \$5979 CLKBUF_X1
X$2283 \$5939 VSS VDD \$5941 CLKBUF_X1
X$2284 \$5940 VSS VDD \$5614 CLKBUF_X1
X$2285 \$5776 VSS VDD \$5602 CLKBUF_X1
X$2288 \$5426 VSS VDD \$I68716 INV_X1
X$2289 \$5604 VSS VDD \$5427 CLKBUF_X1
X$2290 \$5959 VSS VDD \$5777 CLKBUF_X1
X$2291 \$5415 VSS VDD \$5426 CLKBUF_X3
X$2292 \$6154 VSS VDD \$5956 CLKBUF_X1
X$2293 \$6132 VSS VDD \$6150 CLKBUF_X1
X$2294 \$5428 VSS VDD \$5612 CLKBUF_X1
X$2295 \$6150 VSS VDD \$6145 CLKBUF_X1
X$2296 \$6145 VSS VDD \$5779 CLKBUF_X1
X$2298 \$5780 VSS VDD \$5948 CLKBUF_X1
X$2299 \$5944 VSS VDD \$5945 CLKBUF_X1
X$2300 \$5947 VSS VDD \$5949 CLKBUF_X1
X$2322 \$7309 VSS VDD \$8113 CLKBUF_X1
X$2324 VSS \$7552 \$I100371 \$8179 \$8114 \$3006 VDD DFFR_X1
X$2325 VSS \$7556 \$I100493 \$8426 \$7813 \$3006 VDD DFFR_X1
X$2327 \$8187 VSS VDD \$8115 CLKBUF_X1
X$2328 \$8188 VSS VDD \$8116 CLKBUF_X1
X$2330 \$8117 VSS VDD \$7655 CLKBUF_X1
X$2331 \$7906 VSS VDD \$7904 CLKBUF_X1
X$2332 \$7904 VSS VDD \$8194 CLKBUF_X1
X$2333 \$7815 VSS VDD \$7906 CLKBUF_X1
X$2334 \$7907 VSS VDD \$7649 CLKBUF_X1
X$2338 \$8179 VSS VDD \$8406 CLKBUF_X1
X$2339 \$8405 VSS VDD \$8180 CLKBUF_X1
X$2340 \$8409 VSS VDD \$8321 CLKBUF_X1
X$2344 \$6180 VSS VDD \$7552 CLKBUF_X3
X$2345 VSS \$7552 \$I100020 \$8422 \$8180 \$3006 VDD DFFR_X1
X$2346 \$8422 VSS VDD \$8423 CLKBUF_X1
X$2347 \$8873 VSS VDD \$8424 CLKBUF_X1
X$2349 \$8426 VSS VDD \$8187 CLKBUF_X1
X$2350 \$8115 VSS VDD \$8191 CLKBUF_X1
X$2352 \$8194 VSS VDD \$8117 CLKBUF_X1
X$2353 \$6180 VSS VDD \$7556 CLKBUF_X3
X$2354 \$8191 VSS VDD \$8188 CLKBUF_X1
X$2356 \$7819 VSS VDD \$7920 CLKBUF_X1
X$2357 VSS \$7556 \$I100333 \$7918 \$8326 \$3006 VDD DFFR_X1
X$2358 \$8201 VSS VDD \$8441 CLKBUF_X1
X$2359 \$7920 VSS VDD \$7916 CLKBUF_X1
X$2362 \$8329 VSS VDD \$8330 CLKBUF_X1
X$2363 \$6725 VSS VDD \$8331 CLKBUF_X1
X$2364 \$8332 VSS VDD \$7819 CLKBUF_X1
X$2365 \$8441 VSS VDD \$8332 CLKBUF_X1
X$2366 \$7312 VSS VDD \$8597 CLKBUF_X1
X$2367 \$7918 VSS VDD \$8201 CLKBUF_X1
X$2369 \$7922 VSS VDD \$7921 CLKBUF_X1
X$2371 \$7820 VSS VDD \$7923 CLKBUF_X1
X$2374 \$7930 VSS VDD \$8457 CLKBUF_X1
X$2379 \$7829 \$7822 VSS VDD \$8756 NAND2_X1
X$2380 \$7566 \$7321 VSS VDD \$7822 NAND2_X1
X$2381 \$6939 \$7704 VSS VDD \$7938 NAND2_X1
X$2382 \$7826 \$7945 VDD VSS \$7692 AND2_X1
X$2383 \$7568 VSS VDD \$8222 CLKBUF_X1
X$2386 \$8456 \$8119 VSS VDD \$8333 NAND2_X1
X$2389 \$7318 \$8455 \$8724 VDD VSS \$8456 HA_X1
X$2392 \$7821 VSS VDD \$7827 CLKBUF_X1
X$2395 VSS \$7564 \$I99850 \$7832 \$8340 \$6364 VDD DFFR_X1
X$2397 \$8226 \$7955 VDD VSS \$8767 XNOR2_X1
X$2399 \$7704 VSS VDD \$7955 CLKBUF_X1
X$2400 \$7826 \$7832 VDD VSS \$7960 AND2_X1
X$2403 \$7832 \$7945 \$8342 \$8123 VSS VDD \$8230 NOR4_X1
X$2404 \$7953 VSS VDD \$8226 CLKBUF_X1
X$2405 \$7837 VSS VDD \$8122 INV_X1
X$2406 VSS \$7835 \$7953 \$8238 \$7834 \$7836 VDD FA_X1
X$2407 \$7838 VSS VDD \$7839 CLKBUF_X1
X$2408 \$7826 \$8242 VDD VSS \$7970 AND2_X1
X$2410 \$7839 VSS VDD \$8248 CLKBUF_X1
X$2411 VSS \$7578 \$I100248 \$8123 \$8246 \$6364 VDD DFFR_X1
X$2414 \$7976 VSS VDD \$7840 CLKBUF_X1
X$2417 \$7841 VSS VDD \$7986 CLKBUF_X1
X$2418 \$7842 VSS VDD \$7843 CLKBUF_X1
X$2419 \$7985 VSS VDD \$7842 CLKBUF_X1
X$2420 \$7734 VSS VDD \$8257 CLKBUF_X1
X$2421 \$7992 VSS VDD \$7994 CLKBUF_X1
X$2422 \$7994 VSS VDD \$7995 CLKBUF_X1
X$2423 \$7844 VSS VDD \$7997 CLKBUF_X1
X$2424 \$7997 VSS VDD \$8125 CLKBUF_X1
X$2427 \$8496 \$7826 VSS VDD \$7834 NAND2_X1
X$2429 \$8238 VSS VDD \$7837 CLKBUF_X1
X$2430 \$8342 VSS VDD \$8496 CLKBUF_X1
X$2431 VSS \$7578 \$I99954 \$8342 \$8343 \$6364 VDD DFFR_X1
X$2432 \$8123 VSS VDD \$8242 CLKBUF_X1
X$2433 \$8248 VSS VDD \$8246 CLKBUF_X1
X$2436 \$5493 VSS VDD \$7578 CLKBUF_X3
X$2441 \$7995 VSS VDD \$7844 CLKBUF_X1
X$2442 VSS \$6883 \$I100015 \$8346 \$8345 \$6364 VDD DFFR_X1
X$2446 \$7998 VSS VDD \$8001 CLKBUF_X1
X$2447 \$8000 VSS VDD \$7998 CLKBUF_X1
X$2448 \$7580 VSS VDD \$8000 CLKBUF_X1
X$2450 \$7846 VSS VDD \$8019 CLKBUF_X1
X$2451 \$8009 VSS VDD \$8011 CLKBUF_X1
X$2452 VSS \$8127 \$I100468 \$8269 \$8011 \$6364 VDD DFFR_X1
X$2453 \$8019 VSS VDD \$8268 CLKBUF_X1
X$2454 \$8021 VSS VDD \$8024 CLKBUF_X1
X$2455 \$7766 VSS VDD \$8021 CLKBUF_X1
X$2456 \$8024 VSS VDD \$8270 CLKBUF_X1
X$2459 \$8268 VSS VDD \$8029 CLKBUF_X1
X$2462 \$8031 VSS VDD \$7848 CLKBUF_X1
X$2463 VSS \$7582 \$I100177 \$7588 \$7848 \$6364 VDD DFFR_X1
X$2464 VSS \$7589 \$I100214 \$7592 \$8040 \$6364 VDD DFFR_X1
X$2465 VSS \$7589 \$I100208 \$8569 \$8062 \$6763 VDD DFFR_X1
X$2466 VSS \$7589 \$I100509 \$8317 \$7852 \$6763 VDD DFFR_X1
X$2469 \$8512 VSS VDD \$8516 CLKBUF_X1
X$2470 \$8516 VSS VDD \$8348 CLKBUF_X1
X$2473 VSS \$8127 \$I100127 \$8350 \$7183 \$6364 VDD DFFR_X1
X$2476 VSS \$7582 \$I100140 \$8535 \$8528 \$6364 VDD DFFR_X1
X$2478 \$5493 VSS VDD \$7582 CLKBUF_X3
X$2479 \$8532 VSS VDD \$8541 CLKBUF_X1
X$2480 \$7591 VSS VDD \$7590 CLKBUF_X1
X$2481 \$8544 VSS VDD \$8546 CLKBUF_X1
X$2482 \$8546 VSS VDD \$8040 CLKBUF_X1
X$2483 \$7587 VSS VDD \$8544 CLKBUF_X1
X$2484 \$8356 VSS VDD \$8568 CLKBUF_X1
X$2485 VSS \$7589 \$I100049 \$6100 \$8553 \$6364 VDD DFFR_X1
X$2486 \$5666 VSS VDD \$7589 CLKBUF_X3
X$2487 \$8131 VSS VDD \$8294 CLKBUF_X1
X$2488 \$7850 VSS VDD \$8299 CLKBUF_X1
X$2490 \$8305 VSS VDD \$8573 CLKBUF_X1
X$2491 \$8569 VSS VDD \$8360 CLKBUF_X1
X$2492 \$8310 VSS VDD \$7852 CLKBUF_X1
X$2493 \$8361 VSS VDD \$8305 CLKBUF_X1
X$2494 \$8573 VSS VDD \$8310 CLKBUF_X1
X$2496 \$7349 VSS VDD \$8578 CLKBUF_X1
X$2497 VSS \$7594 \$I100073 \$8583 \$8063 \$6763 VDD DFFR_X1
X$2498 \$8135 VSS VDD \$8584 CLKBUF_X1
X$2499 \$7594 VSS VDD \$I93966 CLKBUF_X1
X$2500 \$7856 VSS VDD \$8090 CLKBUF_X1
X$2501 VSS \$7594 \$I100487 \$8366 \$8092 \$6763 VDD DFFR_X1
X$2502 \$8097 VSS VDD \$7596 CLKBUF_X1
X$2503 \$8138 VSS VDD \$8139 CLKBUF_X1
X$2504 VSS \$7594 \$I100340 \$8141 \$8311 \$6763 VDD DFFR_X1
X$2505 VSS \$7189 \$I100375 \$8144 \$8306 \$6763 VDD DFFR_X1
X$2506 VSS \$7189 \$I100431 \$8145 \$8295 \$6763 VDD DFFR_X1
X$2507 \$8106 VSS VDD \$8108 CLKBUF_X1
X$2508 \$8147 VSS VDD \$8106 CLKBUF_X1
X$2509 \$8100 VSS VDD \$8104 CLKBUF_X1
X$2511 \$8136 VSS VDD \$8364 CLKBUF_X1
X$2512 \$8585 VSS VDD \$8580 CLKBUF_X1
X$2513 \$5666 VSS VDD \$7594 CLKBUF_X3
X$2514 \$8581 VSS VDD \$8572 CLKBUF_X1
X$2515 \$8574 VSS VDD \$8311 CLKBUF_X1
X$2516 \$7859 VSS VDD \$8138 CLKBUF_X1
X$2517 VSS \$7594 \$I100041 \$8636 \$8139 \$6763 VDD DFFR_X1
X$2519 \$8367 VSS VDD \$8369 CLKBUF_X1
X$2520 \$8141 VSS VDD \$8367 CLKBUF_X1
X$2521 \$8369 VSS VDD \$8368 CLKBUF_X1
X$2522 \$8142 VSS VDD \$8561 CLKBUF_X1
X$2524 \$8560 VSS VDD \$8559 CLKBUF_X1
X$2525 \$8561 VSS VDD \$8306 CLKBUF_X1
X$2527 \$8856 VSS VDD \$8552 CLKBUF_X1
X$2528 \$8556 VSS VDD \$9047 CLKBUF_X1
X$2529 \$8555 VSS VDD \$8556 CLKBUF_X1
X$2530 \$8552 VSS VDD \$8293 CLKBUF_X1
X$2531 \$8143 VSS VDD \$8295 CLKBUF_X1
X$2534 \$8550 VSS VDD \$8545 CLKBUF_X1
X$2535 \$8144 VSS VDD \$8276 CLKBUF_X1
X$2536 \$8145 VSS VDD \$8147 CLKBUF_X1
X$2538 VSS \$8146 \$I100088 \$8374 \$8372 \$4734 VDD DFFR_X1
X$2539 \$8093 VSS VDD \$7607 CLKBUF_X1
X$2540 \$8087 VSS VDD \$8086 CLKBUF_X1
X$2541 \$8276 VSS VDD \$7862 CLKBUF_X1
X$2542 \$7863 VSS VDD \$8087 CLKBUF_X1
X$2543 \$8373 VSS VDD \$8079 CLKBUF_X1
X$2544 \$8078 VSS VDD \$8150 CLKBUF_X1
X$2545 VSS \$7193 \$I100288 \$7197 \$8071 \$4734 VDD DFFR_X1
X$2546 VSS \$7609 \$I100396 \$7869 \$8038 \$4734 VDD DFFR_X1
X$2547 \$7868 VSS VDD \$8038 CLKBUF_X1
X$2548 \$7869 VSS VDD \$8026 CLKBUF_X1
X$2551 \$8148 VSS VDD \$8078 CLKBUF_X1
X$2552 VSS \$7193 \$I99962 \$8523 \$8375 \$4734 VDD DFFR_X1
X$2556 \$8534 VSS VDD \$8059 CLKBUF_X1
X$2557 \$8376 VSS VDD \$8056 CLKBUF_X1
X$2558 \$8058 VSS VDD \$8052 CLKBUF_X1
X$2560 \$5666 VSS VDD \$7609 CLKBUF_X3
X$2562 \$8154 VSS VDD \$7741 CLKBUF_X1
X$2563 \$8521 VSS VDD \$7868 CLKBUF_X1
X$2565 VSS \$7609 \$I99918 \$8773 \$8519 \$4734 VDD DFFR_X1
X$2566 \$8034 VSS VDD \$8157 CLKBUF_X1
X$2567 \$7870 VSS VDD \$8034 CLKBUF_X1
X$2570 \$8014 VSS VDD \$7972 CLKBUF_X1
X$2571 VSS \$7618 \$I100473 \$8504 \$8243 \$4734 VDD DFFR_X1
X$2572 \$8234 VSS VDD \$7993 CLKBUF_X1
X$2573 \$7873 VSS VDD \$8003 CLKBUF_X1
X$2574 \$8003 VSS VDD \$8232 CLKBUF_X1
X$2575 \$7974 VSS VDD \$7620 CLKBUF_X1
X$2576 \$8232 VSS VDD \$7974 CLKBUF_X1
X$2577 VSS \$7875 \$I100309 \$8483 \$7972 \$4734 VDD DFFR_X1
X$2580 \$8381 VSS VDD \$8518 CLKBUF_X1
X$2581 \$8518 VSS VDD \$8384 CLKBUF_X1
X$2582 \$8513 VSS VDD \$8243 CLKBUF_X1
X$2583 \$8383 VSS VDD \$8509 CLKBUF_X1
X$2584 \$8509 VSS VDD \$8239 CLKBUF_X1
X$2585 \$8158 VSS VDD \$8234 CLKBUF_X1
X$2586 \$8504 VSS VDD \$7873 CLKBUF_X1
X$2587 \$8500 VSS VDD \$8218 CLKBUF_X1
X$2589 \$7874 VSS VDD \$8488 CLKBUF_X1
X$2590 \$8227 VSS VDD \$7876 CLKBUF_X1
X$2591 \$8488 VSS VDD \$8227 CLKBUF_X1
X$2592 \$8487 VSS VDD \$8486 CLKBUF_X1
X$2593 \$8486 VSS VDD \$8484 CLKBUF_X1
X$2594 \$8484 VSS VDD \$7969 CLKBUF_X1
X$2595 \$8925 VSS VDD \$7202 CLKBUF_X1
X$2597 \$8483 VSS VDD \$8480 CLKBUF_X1
X$2598 VSS \$7233 \$I100440 \$8162 \$8203 \$6120 VDD DFFR_X1
X$2599 VSS \$7233 \$I100516 \$8160 \$8212 \$6120 VDD DFFR_X1
X$2601 VSS \$7233 \$I100527 \$6563 \$7883 \$6120 VDD DFFR_X1
X$2603 \$8739 VSS VDD \$8481 CLKBUF_X1
X$2604 \$8481 VSS VDD \$7698 CLKBUF_X1
X$2605 \$8387 VSS VDD \$8210 CLKBUF_X1
X$2606 \$8480 VSS VDD \$8387 CLKBUF_X1
X$2607 \$7958 VSS VDD \$8475 CLKBUF_X1
X$2608 \$8475 VSS VDD \$8212 CLKBUF_X1
X$2609 \$8206 VSS VDD \$8467 CLKBUF_X1
X$2610 \$8160 VSS VDD \$8206 CLKBUF_X1
X$2611 \$8467 VSS VDD \$8474 CLKBUF_X1
X$2612 \$5415 VSS VDD \$7233 CLKBUF_X3
X$2613 \$8471 VSS VDD \$8465 CLKBUF_X1
X$2614 \$8465 VSS VDD \$8203 CLKBUF_X1
X$2615 \$8463 VSS VDD \$7881 CLKBUF_X1
X$2616 \$8391 VSS VDD \$6984 CLKBUF_X1
X$2617 \$8161 VSS VDD \$8197 CLKBUF_X1
X$2618 \$8162 VSS VDD \$8450 CLKBUF_X1
X$2619 \$8448 VSS VDD \$8437 CLKBUF_X1
X$2620 \$8436 VSS VDD \$8393 CLKBUF_X1
X$2622 \$6563 VSS VDD \$7885 CLKBUF_X1
X$2625 \$7877 \$6379 VSS VDD \$8164 NAND2_X1
X$2627 \$8164 VSS VDD \$7901 INV_X1
X$2628 \$7900 \$7901 \$7888 VDD VSS \$8190 HA_X1
X$2635 \$8395 \$6564 VSS VDD \$8429 NAND2_X1
X$2637 \$6987 \$6380 VSS VDD \$8396 NAND2_X1
X$2638 \$8429 VSS VDD \$8412 INV_X1
X$2640 \$6563 \$8168 VSS VDD \$8169 NAND2_X1
X$2641 \$8169 VSS VDD \$8695 INV_X1
X$2642 VSS \$7888 \$8176 \$8171 \$8182 \$7643 VDD FA_X1
X$2648 \$6381 \$7212 VSS VDD \$8170 NAND2_X1
X$2649 \$8170 VSS VDD \$8397 INV_X1
X$2653 \$8171 \$8407 \$8174 VDD VSS \$8685 HA_X1
X$2655 VSS \$7632 \$8398 \$8399 \$8174 \$8403 VDD FA_X1
X$2657 \$6569 \$7889 \$8172 VDD VSS \$8670 HA_X1
X$2665 \$8399 VSS VDD \$8940 INV_X1
X$2677 \$8942 VSS VDD \$9172 CLKBUF_X1
X$2678 \$8320 VSS VDD \$8114 CLKBUF_X1
X$2679 \$9172 VSS VDD \$8593 CLKBUF_X1
X$2680 \$8870 VSS VDD \$9402 CLKBUF_X1
X$2681 \$9094 VSS VDD \$8942 CLKBUF_X1
X$2682 \$9176 VSS VDD \$9175 CLKBUF_X1
X$2683 \$9175 VSS VDD \$8871 CLKBUF_X1
X$2684 \$8424 VSS VDD \$9176 CLKBUF_X1
X$2685 \$8687 VSS VDD \$8873 CLKBUF_X1
X$2692 dxin[6] VSS VDD \$9093 BUF_X1
X$2698 \$9402 VSS VDD \$9094 CLKBUF_X1
X$2701 \$9406 VSS VDD \$9329 CLKBUF_X1
X$2703 \$9179 VSS VDD \$9409 CLKBUF_X1
X$2705 \$8874 VSS VDD \$9179 CLKBUF_X1
X$2710 VSS \$9099 \$I100100 \$9651 \$9095 \$8875 VDD DFFR_X1
X$2711 \$9183 VSS VDD \$9096 CLKBUF_X1
X$2713 VSS \$7556 \$I100379 \$9189 \$9096 \$8875 VDD DFFR_X1
X$2714 \$8876 VSS VDD \$8327 CLKBUF_X1
X$2715 \$8877 VSS VDD \$8958 CLKBUF_X1
X$2717 \$8699 VSS VDD \$8329 CLKBUF_X1
X$2718 \$8597 \$8987 \$8974 VDD VSS \$9197 HA_X1
X$2719 \$9197 VSS VDD \$8878 INV_X1
X$2721 \$8879 \$8880 VSS VDD \$9101 NOR2_X1
X$2723 \$8880 \$9103 \$8881 VDD \$8976 VSS OAI21_X1
X$2725 \$9098 VSS VDD \$9418 CLKBUF_X1
X$2726 \$9420 VSS VDD \$9183 CLKBUF_X1
X$2728 \$8958 VSS VDD \$9184 CLKBUF_X1
X$2729 \$8328 VSS VDD \$9425 CLKBUF_X1
X$2730 \$9189 VSS VDD \$8877 CLKBUF_X1
X$2733 \$9100 VSS VDD \$9334 CLKBUF_X1
X$2736 \$8976 \$8884 VDD VSS \$9102 XNOR2_X1
X$2740 \$9102 VSS VDD \$9335 CLKBUF_X1
X$2741 \$8606 \$8604 VSS VDD \$8880 NAND2_X1
X$2745 \$7564 VSS VDD \$I93983 CLKBUF_X1
X$2746 \$8887 VSS VDD \$7317 CLKBUF_X1
X$2747 \$6180 VSS VDD \$7564 CLKBUF_X3
X$2748 VSS \$7564 \$I100328 \$9106 \$9211 \$8875 VDD DFFR_X1
X$2755 \$9103 \$9104 VDD VSS \$9439 XNOR2_X1
X$2757 \$8606 VSS VDD \$9104 CLKBUF_X1
X$2762 \$9448 VSS VDD \$9338 INV_X1
X$2764 \$9219 VSS VDD \$9572 INV_X1
X$2766 \$9227 \$9009 \$9219 VDD VSS \$9107 HA_X1
X$2768 VSS \$9222 \$9448 \$9900 \$9451 \$9009 VDD FA_X1
X$2769 \$9108 VSS VDD \$9009 INV_X1
X$2772 VSS \$9236 \$9901 \$9696 \$9108 \$9109 VDD FA_X1
X$2774 \$9224 VSS VDD \$9222 INV_X1
X$2775 \$8535 \$8532 VSS VDD \$9108 NAND2_X1
X$2776 \$8535 \$9110 \$9109 VDD \$9227 VSS OAI21_X1
X$2777 \$8535 \$8350 VSS VDD \$9109 NAND2_X1
X$2778 \$8897 \$8350 VSS VDD \$9224 NAND2_X1
X$2781 \$9241 VSS VDD \$9113 CLKBUF_X1
X$2782 \$8892 VSS VDD \$9241 CLKBUF_X1
X$2783 \$9113 VSS VDD \$8344 CLKBUF_X1
X$2784 \$8615 VSS VDD \$9243 CLKBUF_X1
X$2785 \$9243 VSS VDD \$9025 CLKBUF_X1
X$2789 \$9110 \$8897 VSS VDD \$9236 OR2_X1
X$2790 \$7339 \$9110 VSS VDD \$9451 NOR2_X1
X$2794 \$9248 VSS VDD \$9461 CLKBUF_X1
X$2795 \$9465 VSS VDD \$9251 CLKBUF_X1
X$2796 \$9246 VSS VDD \$8894 CLKBUF_X1
X$2797 \$9251 VSS VDD \$9248 CLKBUF_X1
X$2798 \$8893 VSS VDD \$9246 CLKBUF_X1
X$2802 \$9255 VSS VDD \$9114 CLKBUF_X1
X$2803 \$9115 VSS VDD \$9254 CLKBUF_X1
X$2804 \$9254 VSS VDD \$9715 CLKBUF_X1
X$2805 \$9030 VSS VDD \$9255 CLKBUF_X1
X$2808 \$8789 VSS VDD \$9117 CLKBUF_X1
X$2809 \$9259 VSS VDD \$8618 CLKBUF_X1
X$2810 \$9117 VSS VDD \$9259 CLKBUF_X1
X$2811 \$9041 VSS VDD \$8896 CLKBUF_X1
X$2814 \$9261 VSS VDD \$9118 CLKBUF_X1
X$2815 \$8897 VSS VDD \$9261 CLKBUF_X1
X$2816 \$9118 VSS VDD \$8898 CLKBUF_X1
X$2817 \$8619 VSS VDD \$9048 CLKBUF_X1
X$2820 VSS \$9119 \$I100433 \$9122 \$6753 \$6364 VDD DFFR_X1
X$2822 VSS \$8127 \$I99846 \$9580 \$9461 \$6364 VDD DFFR_X1
X$2824 \$9114 VSS VDD \$9115 CLKBUF_X1
X$2825 VSS \$8127 \$9579 \$9473 \$9470 \$6364 VDD DFFR_X1
X$2829 \$9473 VSS VDD \$9110 INV_X1
X$2833 \$9478 VSS VDD \$9481 CLKBUF_X1
X$2835 \$8899 VSS VDD \$9485 CLKBUF_X1
X$2836 \$8622 VSS VDD \$9483 CLKBUF_X1
X$2837 \$9483 VSS VDD \$9271 CLKBUF_X1
X$2838 \$9485 VSS VDD \$9490 CLKBUF_X1
X$2839 \$9490 VSS VDD \$9121 CLKBUF_X1
X$2840 \$9271 VSS VDD \$9497 CLKBUF_X1
X$2841 \$9275 VSS VDD \$6954 CLKBUF_X1
X$2842 \$9062 VSS VDD \$9067 CLKBUF_X1
X$2843 \$9125 VSS VDD \$8356 CLKBUF_X1
X$2844 \$9287 VSS VDD \$9285 CLKBUF_X1
X$2845 \$9285 VSS VDD \$9079 CLKBUF_X1
X$2846 VSS \$7582 \$I100495 \$8629 \$7187 \$6364 VDD DFFR_X1
X$2848 \$9294 VSS VDD \$6918 CLKBUF_X1
X$2849 \$8359 VSS VDD \$9084 CLKBUF_X1
X$2850 \$9298 VSS VDD \$9085 CLKBUF_X1
X$2851 \$8841 VSS VDD \$9298 CLKBUF_X1
X$2852 VSS \$9307 \$I100529 \$9129 \$9303 \$6763 VDD DFFR_X1
X$2853 VSS \$9307 \$I100187 \$8907 \$8905 \$6763 VDD DFFR_X1
X$2854 VSS \$8635 \$I100384 \$8908 \$9322 \$6763 VDD DFFR_X1
X$2855 VSS \$8635 \$I100350 \$9133 \$8909 \$6763 VDD DFFR_X1
X$2856 VSS \$7594 \$I100286 \$8912 \$9132 \$6763 VDD DFFR_X1
X$2857 VSS \$8146 \$I100213 \$9365 \$9134 \$8370 VDD DFFR_X1
X$2858 VSS \$8146 \$I100327 \$8914 \$9306 \$8370 VDD DFFR_X1
X$2859 \$9038 VSS VDD \$9299 CLKBUF_X1
X$2861 \$9122 VSS VDD \$9739 CLKBUF_X1
X$2862 \$9124 VSS VDD \$7338 CLKBUF_X1
X$2863 \$8624 VSS VDD \$9125 CLKBUF_X1
X$2864 \$10113 VSS VDD \$10110 CLKBUF_X1
X$2865 \$9742 VSS VDD \$9752 CLKBUF_X1
X$2866 VSS \$7582 \$I99877 \$9510 \$9498 \$6364 VDD DFFR_X1
X$2867 \$9505 VSS VDD \$9348 CLKBUF_X1
X$2868 \$8630 VSS VDD \$9303 CLKBUF_X1
X$2869 \$9510 VSS VDD \$9508 CLKBUF_X1
X$2870 \$9508 VSS VDD \$9350 CLKBUF_X1
X$2871 \$9514 VSS VDD \$9128 CLKBUF_X1
X$2872 \$9518 VSS VDD \$9520 CLKBUF_X1
X$2873 \$9126 VSS VDD \$9518 CLKBUF_X1
X$2874 \$10569 VSS VDD \$9127 CLKBUF_X1
X$2875 \$9520 VSS VDD \$9524 CLKBUF_X1
X$2876 \$9524 VSS VDD \$9351 CLKBUF_X1
X$2877 \$9129 VSS VDD \$9354 CLKBUF_X1
X$2878 \$9353 VSS VDD \$9514 CLKBUF_X1
X$2879 \$9128 VSS VDD \$9534 CLKBUF_X1
X$2880 \$9534 VSS VDD \$8905 CLKBUF_X1
X$2882 \$9531 VSS VDD \$9537 CLKBUF_X1
X$2883 \$9545 VSS VDD \$9318 CLKBUF_X1
X$2884 \$9537 VSS VDD \$9355 CLKBUF_X1
X$2885 \$9318 VSS VDD \$9322 CLKBUF_X1
X$2886 \$9542 VSS VDD \$9545 CLKBUF_X1
X$2888 \$9543 VSS VDD \$9324 CLKBUF_X1
X$2889 \$9325 VSS VDD \$9327 CLKBUF_X1
X$2890 \$8908 VSS VDD \$9325 CLKBUF_X1
X$2891 \$9555 VSS VDD \$8909 CLKBUF_X1
X$2892 \$9327 VSS VDD \$9543 CLKBUF_X1
X$2893 \$9552 VSS VDD \$9360 CLKBUF_X1
X$2894 \$9324 VSS VDD \$9555 CLKBUF_X1
X$2896 \$8910 VSS VDD \$9323 CLKBUF_X1
X$2897 \$8911 VSS VDD \$9361 CLKBUF_X1
X$2898 \$9549 VSS VDD \$9132 CLKBUF_X1
X$2899 \$9361 VSS VDD \$9549 CLKBUF_X1
X$2901 \$9055 VSS VDD \$9134 CLKBUF_X1
X$2904 \$8912 VSS VDD \$9604 CLKBUF_X1
X$2905 \$9133 VSS VDD \$9313 CLKBUF_X1
X$2906 \$9544 VSS VDD \$9362 CLKBUF_X1
X$2907 VSS \$9135 \$I100099 \$9308 \$9363 \$6763 VDD DFFR_X1
X$2908 VSS \$8146 \$I100079 \$9839 \$9528 \$8370 VDD DFFR_X1
X$2910 VSS \$8146 \$I100011 \$8916 \$9512 \$8370 VDD DFFR_X1
X$2911 \$9513 VSS VDD \$9512 CLKBUF_X1
X$2912 \$9297 VSS VDD \$9138 CLKBUF_X1
X$2913 \$9299 VSS VDD \$9014 CLKBUF_X1
X$2915 \$9140 VSS VDD \$9139 CLKBUF_X1
X$2916 \$9139 VSS VDD \$8373 CLKBUF_X1
X$2917 \$9295 VSS VDD \$9141 CLKBUF_X1
X$2918 \$8916 VSS VDD \$9295 CLKBUF_X1
X$2919 VSS \$7609 \$I100212 \$9283 \$9292 \$8370 VDD DFFR_X1
X$2920 \$9277 VSS VDD \$8802 CLKBUF_X1
X$2921 \$8658 VSS VDD \$8918 CLKBUF_X1
X$2922 \$9283 VSS VDD \$9008 CLKBUF_X1
X$2923 \$7866 VSS VDD \$8043 CLKBUF_X1
X$2925 \$9269 VSS VDD \$9270 CLKBUF_X1
X$2927 \$9270 VSS VDD \$9002 CLKBUF_X1
X$2928 \$8157 VSS VDD \$8519 CLKBUF_X1
X$2931 \$7618 VSS VDD \$I93294 CLKBUF_X1
X$2933 \$9509 VSS VDD \$9369 CLKBUF_X1
X$2934 VSS \$9781 \$I100071 \$8658 \$9142 \$8370 VDD DFFR_X1
X$2938 \$9500 VSS VDD \$9503 CLKBUF_X1
X$2939 \$9503 VSS VDD \$9145 CLKBUF_X1
X$2940 \$9146 VSS VDD \$9496 CLKBUF_X1
X$2941 \$9496 VSS VDD \$9012 CLKBUF_X1
X$2945 \$9153 VSS VDD \$9491 CLKBUF_X1
X$2946 \$9491 VSS VDD \$9488 CLKBUF_X1
X$2947 \$9484 VSS VDD \$9375 CLKBUF_X1
X$2948 \$9488 VSS VDD \$9269 CLKBUF_X1
X$2953 \$9377 VSS VDD \$9379 CLKBUF_X1
X$2954 VSS \$7618 \$I100074 \$9472 \$9480 \$6120 VDD DFFR_X1
X$2955 \$8652 VSS VDD \$9266 CLKBUF_X1
X$2957 \$9266 VSS VDD \$9264 CLKBUF_X1
X$2958 \$9264 VSS VDD \$8991 CLKBUF_X1
X$2959 \$8653 VSS VDD \$9262 CLKBUF_X1
X$2960 \$9262 VSS VDD \$8654 CLKBUF_X1
X$2962 \$9380 VSS VDD \$8385 CLKBUF_X1
X$2965 \$9472 VSS VDD \$9476 CLKBUF_X1
X$2966 \$8923 VSS VDD \$8922 CLKBUF_X1
X$2967 \$8922 VSS VDD \$9148 CLKBUF_X1
X$2968 \$9148 VSS VDD \$9249 CLKBUF_X1
X$2969 \$9249 VSS VDD \$9464 CLKBUF_X1
X$2970 \$9252 VSS VDD \$8925 CLKBUF_X1
X$2971 \$9245 VSS VDD \$7875 CLKBUF_X3
X$2972 \$8761 VSS VDD \$8758 CLKBUF_X1
X$2973 \$8973 VSS VDD \$9242 CLKBUF_X1
X$2974 \$9242 VSS VDD \$8967 CLKBUF_X1
X$2976 VSS \$7875 \$I100485 \$9149 \$9235 \$6120 VDD DFFR_X1
X$2977 \$8722 VSS VDD \$8951 CLKBUF_X1
X$2978 \$8928 VSS VDD \$9150 CLKBUF_X1
X$2979 \$9221 VSS VDD \$9218 CLKBUF_X1
X$2980 \$9218 VSS VDD \$8954 CLKBUF_X1
X$2982 \$6986 VSS VDD \$8161 CLKBUF_X1
X$2986 \$9147 VSS VDD \$9252 CLKBUF_X1
X$2987 VSS \$7875 \$I100060 \$9463 \$9460 \$6120 VDD DFFR_X1
X$2989 \$9463 VSS VDD \$9459 CLKBUF_X1
X$2990 \$9459 VSS VDD \$9458 CLKBUF_X1
X$2991 \$9458 VSS VDD \$9234 CLKBUF_X1
X$2992 \$9385 VSS VDD \$8739 CLKBUF_X1
X$2993 \$9453 VSS VDD \$9447 CLKBUF_X1
X$2994 \$9234 VSS VDD \$9453 CLKBUF_X1
X$2995 \$9447 VSS VDD \$9235 CLKBUF_X1
X$2996 \$9445 VSS VDD \$9221 CLKBUF_X1
X$2997 \$9149 VSS VDD \$8928 CLKBUF_X1
X$2998 \$9150 VSS VDD \$9445 CLKBUF_X1
X$2999 \$9386 VSS VDD \$9151 CLKBUF_X1
X$3002 \$6564 \$9152 VSS VDD \$9702 NOR2_X1
X$3004 \$9153 \$6563 VSS VDD \$9154 NAND2_X1
X$3006 \$9154 VSS VDD \$9389 INV_X1
X$3007 \$9153 \$6564 VSS VDD \$9156 NAND2_X1
X$3009 \$8395 \$6563 VSS VDD \$9157 NAND2_X1
X$3010 \$9157 VSS VDD \$9158 INV_X1
X$3017 \$6563 \$9152 VSS VDD \$9391 NOR2_X1
X$3018 \$9156 VSS VDD \$9435 INV_X1
X$3019 \$9158 \$9435 \$9193 VDD VSS \$9429 HA_X1
X$3022 \$7877 \$7212 VSS VDD \$9161 NAND2_X1
X$3023 \$9161 VSS VDD \$9395 INV_X1
X$3026 \$8948 VSS VDD \$9411 INV_X1
X$3027 \$6987 \$7212 VSS VDD \$9162 NAND2_X1
X$3028 \$9162 VSS VDD \$9408 INV_X1
X$3029 \$9415 VSS VDD \$9405 INV_X1
X$3031 \$9403 \$9193 \$9163 VDD VSS \$9653 HA_X1
X$3034 \$8935 \$8934 VDD VSS \$9397 XNOR2_X1
X$3035 \$8934 VSS VDD \$9164 INV_X1
X$3037 \$8935 \$9164 \$8681 VDD \$8933 VSS OAI21_X1
X$3038 \$9166 \$8936 \$8670 VSS \$9165 VDD AOI21_X1
X$3039 \$9169 \$9164 \$8681 VDD \$9166 VSS OAI21_X1
X$3040 \$8667 VSS VDD \$9169 INV_X1
X$3049 \$9401 VSS VDD \$9398 INV_X1
X$3063 \$10021 VSS VDD \$10022 CLKBUF_X1
X$3065 \$10024 VSS VDD \$9962 CLKBUF_X1
X$3066 \$10026 VSS VDD \$10024 CLKBUF_X1
X$3067 \$9962 VSS VDD \$10209 CLKBUF_X1
X$3068 \$10022 VSS VDD \$10026 CLKBUF_X1
X$3069 \$10034 VSS VDD \$9860 CLKBUF_X1
X$3070 VSS \$9560 \$I100447 \$10153 \$10031 \$8875 VDD DFFR_X1
X$3071 \$9965 VSS VDD \$9862 CLKBUF_X1
X$3075 \$10209 VSS VDD \$10210 CLKBUF_X1
X$3076 VSS \$9560 \$I100111 \$10365 \$10210 \$8875 VDD DFFR_X1
X$3077 \$10878 VSS VDD \$10366 CLKBUF_X1
X$3079 \$10435 VSS VDD \$10151 CLKBUF_X1
X$3080 \$10530 VSS VDD \$10222 CLKBUF_X1
X$3081 \$10222 VSS VDD \$10220 CLKBUF_X1
X$3082 \$10220 VSS VDD \$10435 CLKBUF_X1
X$3083 \$10153 VSS VDD \$9965 CLKBUF_X1
X$3085 \$9563 \$10447 \$10154 VDD \$10440 VSS OAI21_X1
X$3086 \$10370 VSS VDD \$10154 INV_X1
X$3087 \$9662 \$10157 \$9563 VDD \$10369 VSS OAI21_X1
X$3088 \$10447 \$9662 \$10232 VSS VDD \$9564 NOR3_X1
X$3090 \$11409 VSS VDD \$11475 CLKBUF_X1
X$3091 VSS \$11109 \$I100313 \$11616 \$11029 \$8875 VDD DFFR_X1
X$3093 \$11362 VSS VDD \$11359 CLKBUF_X1
X$3094 \$11301 VSS VDD \$11480 CLKBUF_X1
X$3095 \$11363 VSS VDD \$11558 CLKBUF_X1
X$3096 \$11480 VSS VDD \$11363 CLKBUF_X1
X$3098 \$11302 VSS VDD \$11365 CLKBUF_X1
X$3108 \$11614 VSS VDD \$11408 CLKBUF_X1
X$3109 \$11557 VSS VDD \$11620 CLKBUF_X1
X$3110 \$11475 VSS VDD \$11557 CLKBUF_X1
X$3111 \$11616 VSS VDD \$11409 CLKBUF_X1
X$3112 \$11620 VSS VDD \$11614 CLKBUF_X1
X$3115 \$11558 VSS VDD \$11030 CLKBUF_X1
X$3118 VSS \$11109 \$I99965 \$11560 \$11410 \$8875 VDD DFFR_X1
X$3119 \$11485 VSS VDD \$11410 CLKBUF_X1
X$3121 \$11031 VSS VDD \$11485 CLKBUF_X1
X$3124 \$11412 \$11036 VDD VSS \$11797 XNOR2_X1
X$3126 \$11037 VSS VDD \$11036 INV_X1
X$3128 \$11034 \$11561 \$11037 VDD VSS \$11411 HA_X1
X$3130 \$11411 VSS VDD \$11038 INV_X1
X$3133 \$11411 \$11037 \$11412 VSS \$11631 VDD AOI21_X1
X$3136 \$11562 VSS VDD \$11563 INV_X1
X$3137 \$11413 VSS VDD \$11562 CLKBUF_X1
X$3139 \$9670 \$11563 VDD VSS \$11638 XNOR2_X1
X$3140 \$11564 \$11413 \$9670 VSS VDD \$11640 NAND3_X1
X$3141 \$11034 \$11645 \$11564 VDD VSS \$11749 HA_X1
X$3142 VSS \$11109 \$I100138 \$11419 \$11638 \$8875 VDD DFFR_X1
X$3144 \$11305 \$7826 VSS VDD \$11561 NAND2_X1
X$3146 \$11150 VSS VDD \$11034 CLKBUF_X1
X$3148 \$11414 VSS VDD \$11305 INV_X1
X$3149 \$11418 \$11306 VSS VDD \$7826 NOR2_X2
X$3151 \$11420 \$11305 \$11307 VSS VDD \$11509 NAND3_X1
X$3153 \$11307 \$11414 \$11420 VDD VSS \$10543 AND3_X1
X$3154 \$11509 \$11566 VDD VSS \$11149 XNOR2_X1
X$3155 \$11308 VSS VDD \$11042 CLKBUF_X1
X$3156 \$11423 \$11306 VSS VDD \$11424 NOR2_X1
X$3159 \$11310 VSS VDD \$11664 CLKBUF_X1
X$3162 \$11043 \$11388 \$11666 VDD VSS \$11667 HA_X1
X$3166 \$11519 VSS VDD \$11426 INV_X1
X$3168 VSS \$11428 \$11519 \$11671 \$11049 \$11390 VDD FA_X1
X$3171 \$11644 \$11306 VSS VDD \$11645 NOR2_X1
X$3172 \$11418 \$11421 VSS VDD \$11644 NOR2_X1
X$3173 \$11419 VSS VDD \$11420 INV_X1
X$3174 \$11419 \$11414 \$11421 \$11654 VSS VDD \$11653 NAND4_X1
X$3175 \$11421 \$11654 VSS VDD \$11307 NOR2_X1
X$3177 \$11566 \$11653 \$11418 VDD VSS \$11423 HA_X1
X$3179 \$11656 VSS VDD \$11655 CLKBUF_X1
X$3181 \$11424 \$11662 VSS VDD \$11425 XOR2_X1
X$3183 \$11663 VSS VDD \$11662 CLKBUF_X1
X$3184 \$11664 VSS VDD \$11663 CLKBUF_X1
X$3188 \$11666 VSS VDD \$11567 INV_X1
X$3190 \$11667 VSS VDD \$11830 INV_X1
X$3194 VSS \$11670 \$11757 \$11878 \$11311 \$11426 VDD FA_X1
X$3196 VSS \$11675 \$11670 \$11962 \$10548 \$11674 VDD FA_X1
X$3197 \$11671 VSS VDD \$11674 INV_X1
X$3199 VSS \$11428 \$11568 \$11759 \$11049 \$11569 VDD FA_X1
X$3200 VSS \$11429 \$11569 \$11526 \$11525 \$10928 VDD FA_X1
X$3203 \$11526 VSS VDD \$11394 INV_X1
X$3205 VSS \$10379 \$11879 \$11431 \$10476 \$11394 VDD FA_X1
X$3208 \$11049 VSS VDD \$11530 INV_X1
X$3209 VSS \$11530 \$11880 \$11572 \$10483 \$11314 VDD FA_X1
X$3212 \$11315 VSS VDD \$11688 INV_X1
X$3213 \$11318 \$11399 \$11536 VDD VSS \$11432 HA_X1
X$3217 VSS \$11678 \$11570 \$11684 \$11049 \$11428 VDD FA_X1
X$3218 \$11684 VSS VDD \$11683 INV_X1
X$3224 VSS \$10811 \$11881 \$11573 \$10810 \$11572 VDD FA_X1
X$3227 VSS \$11688 \$11761 \$11762 \$11185 \$11432 VDD FA_X1
X$3230 \$11058 \$10814 \$11692 VDD VSS \$11434 HA_X1
X$3232 \$11319 VSS VDD \$11575 INV_X1
X$3233 \$10818 \$10817 \$11700 VDD VSS \$11435 HA_X1
X$3239 VSS \$11536 \$11574 \$11763 \$11695 \$11697 VDD FA_X1
X$3240 \$11320 \$11575 \$11698 VDD VSS \$11697 HA_X1
X$3241 \$12149 VSS VDD \$11540 CLKBUF_X1
X$3244 \$11576 VSS VDD \$11856 INV_X1
X$3245 \$11321 VSS VDD \$11703 INV_X1
X$3247 \$11064 VSS VDD \$11323 INV_X1
X$3252 \$11324 VSS VDD \$11437 INV_X1
X$3253 \$11577 VSS VDD \$10565 CLKBUF_X1
X$3255 \$11547 VSS VDD \$11550 INV_X1
X$3256 \$11325 VSS VDD \$11439 INV_X1
X$3257 \$11551 VSS VDD \$10387 CLKBUF_X1
X$3258 VSS \$12600 \$I100503 \$11556 \$11225 \$10386 VDD DFFR_X1
X$3260 \$11556 VSS VDD \$11396 CLKBUF_X1
X$3261 VSS \$11440 \$I100460 \$11441 \$11554 \$10386 VDD DFFR_X1
X$3262 VSS \$10181 \$I100204 \$11584 \$11442 \$10386 VDD DFFR_X1
X$3269 \$11550 \$11439 \$11889 VDD VSS \$11704 HA_X1
X$3273 \$11396 VSS VDD \$11707 CLKBUF_X1
X$3274 \$11707 VSS VDD \$11578 CLKBUF_X1
X$3275 clock VSS VDD \$2886 CLKBUF_X3
X$3277 \$11581 VSS VDD \$11715 CLKBUF_X1
X$3278 \$11715 VSS VDD \$11554 CLKBUF_X1
X$3281 \$11716 VSS VDD \$11718 CLKBUF_X1
X$3282 \$11441 VSS VDD \$11716 CLKBUF_X1
X$3283 \$11718 VSS VDD \$11582 CLKBUF_X1
X$3284 \$11583 VSS VDD \$11720 CLKBUF_X1
X$3285 \$11720 VSS VDD \$11442 CLKBUF_X1
X$3289 \$11584 VSS VDD \$11724 CLKBUF_X1
X$3292 \$11724 VSS VDD \$11732 CLKBUF_X1
X$3293 \$9773 \$9133 VSS VDD \$11545 NAND2_X1
X$3294 \$7354 \$10835 VSS VDD \$11861 NOR2_X1
X$3295 \$11545 VSS VDD \$11855 INV_X1
X$3298 \$11735 VSS VDD \$11737 INV_X1
X$3300 \$11732 VSS VDD \$11731 CLKBUF_X1
X$3301 \$8317 \$11584 VSS VDD \$11444 NAND2_X1
X$3302 \$11444 VSS VDD \$11588 INV_X1
X$3304 \$11731 VSS VDD \$11535 CLKBUF_X1
X$3305 VSS \$11722 \$11589 \$11591 \$11728 \$11725 VDD FA_X1
X$3306 \$11333 VSS VDD \$11728 INV_X1
X$3309 \$11539 VSS VDD \$9306 CLKBUF_X1
X$3310 \$11334 VSS VDD \$11722 INV_X1
X$3312 \$11538 VSS VDD \$11335 INV_X1
X$3317 \$7354 \$11074 VSS VDD \$11449 NAND2_X1
X$3318 \$11449 VSS VDD \$11712 INV_X1
X$3319 VSS \$11452 \$11592 \$11593 \$11712 \$11451 VDD FA_X1
X$3320 \$11535 VSS VDD \$11529 CLKBUF_X1
X$3322 \$8636 \$10578 VSS VDD \$11450 NAND2_X1
X$3323 \$11450 VSS VDD \$11451 INV_X1
X$3325 \$11524 VSS VDD \$9015 CLKBUF_X1
X$3326 VSS \$11084 \$I100315 \$11691 \$11529 \$8370 VDD DFFR_X1
X$3328 \$11455 VSS VDD \$11457 CLKBUF_X1
X$3330 \$11339 VSS VDD \$11340 CLKBUF_X1
X$3331 \$11458 VSS VDD \$11339 CLKBUF_X1
X$3332 \$11340 VSS VDD \$11296 CLKBUF_X1
X$3337 \$11594 VSS VDD \$11452 INV_X1
X$3339 \$9133 \$11584 VSS VDD \$11594 NAND2_X1
X$3343 \$8144 \$11584 VSS VDD \$11454 NAND2_X1
X$3344 \$11454 VSS VDD \$11596 INV_X1
X$3346 \$7354 \$10578 VSS VDD \$12013 NAND2_X1
X$3348 \$11691 VSS VDD \$11455 CLKBUF_X1
X$3349 \$11457 VSS VDD \$11458 CLKBUF_X1
X$3351 \$11518 VSS VDD \$11459 CLKBUF_X1
X$3352 \$11288 VSS VDD \$11380 CLKBUF_X1
X$3353 \$11341 VSS VDD \$11518 CLKBUF_X1
X$3354 \$11459 VSS VDD \$10844 CLKBUF_X1
X$3355 \$11085 VSS VDD \$11517 CLKBUF_X1
X$3356 \$11517 VSS VDD \$11285 CLKBUF_X1
X$3362 \$11686 \$11373 \$11822 VDD VSS \$11599 HA_X1
X$3363 \$10849 VSS VDD \$11373 INV_X1
X$3365 VSS \$11342 \$11687 \$11681 \$11252 \$11373 VDD FA_X1
X$3368 \$11515 VSS VDD \$11815 INV_X1
X$3371 VSS \$11345 \$11513 \$11665 \$11461 \$11344 VDD FA_X1
X$3374 \$11510 VSS VDD \$11660 INV_X1
X$3377 \$11687 VSS VDD \$11682 INV_X1
X$3380 \$11681 VSS VDD \$11679 INV_X1
X$3384 \$11677 VSS VDD \$11602 INV_X1
X$3387 \$11344 VSS VDD \$11601 INV_X1
X$3390 \$11461 VSS VDD \$11603 INV_X1
X$3393 VSS \$11462 \$11786 \$11915 \$11661 \$11665 VDD FA_X1
X$3394 VSS \$11463 \$11916 \$11657 \$11660 \$11603 VDD FA_X1
X$3395 \$11346 VSS VDD \$11463 INV_X1
X$3399 VSS \$11364 \$11604 \$11651 \$11464 \$11502 VDD FA_X1
X$3402 \$11923 \$11348 \$11101 \$11468 VSS VDD \$11360 NAND4_X1
X$3404 \$11491 VSS VDD \$11466 INV_X1
X$3405 \$11102 \$11101 \$11468 VSS \$11467 VDD AOI21_X1
X$3406 \$11102 VSS VDD \$11350 INV_X1
X$3407 \$11350 \$11351 VSS VDD \$11626 NAND2_X1
X$3409 \$11657 VSS VDD \$11502 INV_X1
X$3411 VSS \$10858 \$12188 \$11650 \$11651 \$11605 VDD FA_X1
X$3414 VSS \$11465 \$11917 \$11648 \$11650 \$10606 VDD FA_X1
X$3415 \$11648 VSS VDD \$11606 INV_X1
X$3417 \$10607 VSS VDD \$11807 INV_X1
X$3421 \$11348 VSS VDD \$11608 INV_X1
X$3422 \$11466 \$11607 VSS VDD \$11500 NAND2_X1
X$3424 \$11348 \$11626 VSS VDD \$11607 NAND2_X1
X$3426 \$11608 \$11467 \$11466 VDD \$11951 VSS OAI21_X1
X$3427 \$11350 \$11608 \$11466 VDD \$11949 VSS OAI21_X1
X$3429 \$9165 \$11101 VDD VSS \$11470 XNOR2_X1
X$3430 \$9165 VSS VDD \$11468 INV_X1
X$3433 \$11471 \$10610 VSS VDD \$11477 NAND2_X1
X$3434 \$10861 \$11472 \$11476 \$11477 \$10017 VDD VSS \$11926 OAI221_X1
X$3437 \$11354 VSS VDD \$11476 INV_X1
X$3446 \$11626 \$11608 VDD VSS \$11469 XNOR2_X1
X$3447 VSS \$11790 \$I99920 \$11624 \$11470 \$9850 VDD DFFR_X1
X$3448 \$11624 VSS VDD \$11623 CLKBUF_X1
X$3449 \$11623 \$11613 \$11471 VDD VSS \$11354 HA_X1
X$3453 \$11471 VSS VDD \$11621 CLKBUF_X1
X$3455 \$10421 \$11611 VDD VSS \$11613 AND2_X1
X$3464 \$5434 VSS VDD \$6337 CLKBUF_X1
X$3466 \$6137 VSS VDD \$6139 CLKBUF_X1
X$3467 \$6392 VSS VDD \$6137 CLKBUF_X1
X$3468 \$5789 VSS VDD \$6143 CLKBUF_X1
X$3469 \$6143 VSS VDD \$5788 CLKBUF_X1
X$3470 \$6397 VSS VDD \$6151 CLKBUF_X1
X$3471 VSS \$5715 \$I100413 \$6413 \$6149 \$3006 VDD DFFR_X1
X$3475 dxin[2] VSS VDD \$5224 BUF_X1
X$3476 \$6337 VSS VDD \$6135 CLKBUF_X1
X$3477 \$5894 VSS VDD \$6392 CLKBUF_X1
X$3481 \$6577 VSS VDD \$6149 CLKBUF_X1
X$3482 \$5715 VSS VDD \$I92109 CLKBUF_X1
X$3483 \$5718 VSS VDD \$6497 CLKBUF_X1
X$3484 \$5717 VSS VDD \$6397 CLKBUF_X1
X$3485 \$6413 VSS VDD \$6405 CLKBUF_X1
X$3486 \$6180 VSS VDD \$5715 CLKBUF_X3
X$3487 VSS \$5715 \$I99852 \$6062 \$6590 \$3006 VDD DFFR_X1
X$3488 \$6594 VSS VDD \$6504 CLKBUF_X1
X$3489 \$6159 VSS VDD \$6339 CLKBUF_X1
X$3490 \$6596 VSS VDD \$6419 CLKBUF_X1
X$3491 \$6163 VSS VDD \$6061 CLKBUF_X1
X$3492 \$6062 VSS VDD \$6163 CLKBUF_X1
X$3493 \$6603 VSS VDD \$6423 CLKBUF_X1
X$3494 \$6164 VSS VDD \$5958 CLKBUF_X1
X$3495 \$6063 VSS VDD \$5723 CLKBUF_X1
X$3497 \$6170 VSS VDD \$5899 CLKBUF_X1
X$3498 \$6064 VSS VDD \$6341 CLKBUF_X1
X$3503 VSS \$6340 \$I99988 \$6608 \$6423 \$3006 VDD DFFR_X1
X$3504 VSS \$5366 \$I99953 \$6725 \$320 \$3006 VDD DFFR_X1
X$3507 VSS \$5366 \$I99875 \$6619 \$6618 \$3006 VDD DFFR_X1
X$3508 \$6180 VSS VDD \$5366 CLKBUF_X3
X$3509 \$6176 VSS VDD \$6066 CLKBUF_X1
X$3511 \$6068 VSS VDD \$6344 CLKBUF_X1
X$3513 \$6070 VSS VDD \$6071 CLKBUF_X1
X$3516 \$6072 VSS VDD \$6189 CLKBUF_X1
X$3519 \$6073 VSS VDD \$6074 CLKBUF_X1
X$3520 \$3993 VSS VDD \$6348 CLKBUF_X1
X$3521 \$6513 VSS VDD \$6075 CLKBUF_X1
X$3523 VSS \$5366 \$I100007 \$6627 \$6509 \$3006 VDD DFFR_X1
X$3525 \$6832 VSS VDD \$6631 CLKBUF_X1
X$3526 VSS \$4954 \$I99834 \$6512 \$6732 \$3006 VDD DFFR_X1
X$3527 \$3006 VSS VDD \$3833 BUF_X2
X$3528 VSS \$6440 \$I99824 \$6642 \$2577 \$6364 VDD DFFR_X1
X$3529 \$6205 VSS VDD \$6634 CLKBUF_X1
X$3531 \$6002 VSS VDD \$5733 CLKBUF_X1
X$3532 \$6004 VSS VDD \$5734 CLKBUF_X1
X$3533 VSS \$5735 \$I100202 \$6078 \$6448 \$3833 VDD DFFR_X1
X$3534 VSS \$5735 \$I100520 \$6467 \$6219 \$3833 VDD DFFR_X1
X$3535 VSS \$5735 \$5740 \$I87375 \$6081 \$3833 VDD DFFR_X1
X$3536 \$6233 VSS VDD \$6232 CLKBUF_X1
X$3537 \$6232 VSS VDD \$6236 CLKBUF_X1
X$3538 \$6235 VSS VDD \$6234 CLKBUF_X1
X$3539 \$6241 VSS VDD \$6084 CLKBUF_X1
X$3540 \$6478 VSS VDD \$6352 CLKBUF_X1
X$3541 VSS \$6087 \$I100387 \$6085 \$6084 \$3833 VDD DFFR_X1
X$3542 VSS \$6087 \$I100407 \$6358 \$6524 \$45 VDD DFFR_X1
X$3543 \$5385 VSS VDD \$6355 CLKBUF_X1
X$3546 \$6278 \$45 VDD VSS \$6276 AND2_X1
X$3549 \$6634 VSS VDD \$6639 CLKBUF_X1
X$3550 \$6639 VSS VDD \$6448 CLKBUF_X1
X$3551 \$6643 VSS VDD \$6645 CLKBUF_X1
X$3552 \$6649 VSS VDD \$6461 CLKBUF_X1
X$3553 \$6078 VSS VDD \$6649 CLKBUF_X1
X$3554 \$6460 VSS VDD \$6219 CLKBUF_X1
X$3555 \$6461 VSS VDD \$6643 CLKBUF_X1
X$3556 \$6645 VSS VDD \$6460 CLKBUF_X1
X$3558 \$6515 VSS VDD \$6657 CLKBUF_X1
X$3559 \$6467 VSS VDD \$6515 CLKBUF_X1
X$3560 \$6468 VSS VDD \$6081 CLKBUF_X1
X$3561 \$6657 VSS VDD \$6516 CLKBUF_X1
X$3562 \$6350 VSS VDD \$6517 CLKBUF_X1
X$3563 \$6742 VSS VDD \$6468 CLKBUF_X1
X$3564 \$6861 VSS VDD \$6663 CLKBUF_X1
X$3566 \$6661 VSS VDD \$6026 CLKBUF_X1
X$3567 \$5580 VSS VDD \$6667 CLKBUF_X1
X$3568 VSS \$6087 \$I99891 \$6745 \$6351 \$3833 VDD DFFR_X1
X$3569 VSS \$6087 \$I100024 \$6688 \$6675 \$3833 VDD DFFR_X1
X$3570 \$3833 VSS VDD \$45 BUF_X2
X$3571 \$6088 VSS VDD \$6526 CLKBUF_X1
X$3572 VSS \$6087 \$I100056 \$6701 \$6527 \$45 VDD DFFR_X1
X$3576 \$6470 \$5700 VSS VDD \$6698 NOR2_X1
X$3577 \$5700 \$4711 VSS VDD \$6519 NOR2_X1
X$3579 \$6701 VSS VDD \$6486 CLKBUF_X1
X$3580 \$6358 VSS VDD \$6482 CLKBUF_X1
X$3583 \$6486 VSS VDD \$5197 INV_X1
X$3585 \$6482 \$6529 \$3266 VDD VSS \$6281 HA_X1
X$3586 \$6470 VSS VDD \$5875 INV_X1
X$3592 VSS \$5744 \$I100064 \$6532 \$5878 \$6364 VDD DFFR_X1
X$3594 \$6287 VSS VDD \$6359 CLKBUF_X1
X$3596 \$6093 \$6094 VDD VSS \$6278 XNOR2_X1
X$3597 \$6473 \$6303 \$6477 VDD VSS \$6299 HA_X1
X$3598 \$6098 VSS VDD \$6303 INV_X1
X$3600 \$6099 VSS VDD \$6536 CLKBUF_X1
X$3604 \$6477 \$6094 \$6361 VSS VDD \$6095 NAND3_X1
X$3605 VSS \$6715 \$6093 \$6470 \$6098 \$6920 VDD FA_X1
X$3606 \$5399 VSS VDD \$6535 CLKBUF_X1
X$3608 \$6465 VSS VDD \$6714 INV_X1
X$3610 VSS \$4525 \$I100314 \$5867 \$6313 \$6364 VDD DFFR_X1
X$3611 \$6100 \$6315 \$6094 VDD VSS \$6309 HA_X1
X$3612 \$6102 VSS VDD \$6315 INV_X1
X$3614 \$6106 \$5919 VDD VSS \$6098 XNOR2_X1
X$3615 \$6106 \$5919 VDD VSS \$6107 AND2_X1
X$3621 VSS \$4525 \$I100038 \$6759 \$5401 \$6364 VDD DFFR_X1
X$3622 \$5666 VSS VDD \$4525 CLKBUF_X3
X$3625 \$6111 \$6108 VDD VSS \$6465 XNOR2_X1
X$3627 \$6112 \$6109 VSS VDD \$6106 NAND2_X1
X$3628 \$6108 \$6111 VSS VDD \$6109 NAND2_X1
X$3629 \$6108 VSS VDD \$6110 INV_X1
X$3638 \$6365 VSS VDD \$6113 CLKBUF_X1
X$3640 \$6705 VSS VDD \$5594 CLKBUF_X1
X$3641 \$6457 VSS VDD \$6114 CLKBUF_X1
X$3645 \$6709 VSS VDD \$6365 CLKBUF_X1
X$3648 VSS \$4075 \$I100069 \$6543 \$6541 \$4734 VDD DFFR_X1
X$3649 VSS \$4075 \$I100274 \$6270 \$6453 \$4734 VDD DFFR_X1
X$3651 \$6270 VSS VDD \$6272 CLKBUF_X1
X$3653 \$6544 VSS VDD \$6546 CLKBUF_X1
X$3654 \$6366 VSS VDD \$6545 CLKBUF_X1
X$3655 \$6546 VSS VDD \$6453 CLKBUF_X1
X$3657 \$6367 VSS VDD \$5927 CLKBUF_X1
X$3659 \$6115 VSS VDD \$5762 CLKBUF_X1
X$3661 VSS \$6116 \$I100439 \$2007 \$6442 \$4734 VDD DFFR_X1
X$3668 \$6693 VSS VDD \$6115 CLKBUF_X1
X$3669 \$6876 VSS VDD \$6693 CLKBUF_X1
X$3670 \$6443 VSS VDD \$6548 CLKBUF_X1
X$3671 \$6684 VSS VDD \$6687 CLKBUF_X1
X$3672 \$6687 VSS VDD \$6443 CLKBUF_X1
X$3673 \$6548 VSS VDD \$6442 CLKBUF_X1
X$3676 \$6867 VSS VDD \$6679 CLKBUF_X1
X$3681 VSS \$6116 \$I100236 \$2606 \$6249 \$4734 VDD DFFR_X1
X$3682 VSS \$5988 \$I100174 \$6669 \$6437 \$4734 VDD DFFR_X1
X$3685 VSS \$5988 \$I100484 \$2251 \$6426 \$6120 VDD DFFR_X1
X$3687 \$6677 VSS VDD \$6437 CLKBUF_X1
X$3688 \$6674 VSS VDD \$6676 CLKBUF_X1
X$3689 \$6676 VSS VDD \$6677 CLKBUF_X1
X$3692 \$6436 VSS VDD \$6435 CLKBUF_X1
X$3693 \$6668 VSS VDD \$6434 CLKBUF_X1
X$3694 \$6669 VSS VDD \$6668 CLKBUF_X1
X$3695 \$6434 VSS VDD \$6436 CLKBUF_X1
X$3696 \$6435 VSS VDD \$6660 CLKBUF_X1
X$3697 \$6660 VSS VDD \$6249 CLKBUF_X1
X$3700 \$6655 VSS VDD \$6432 CLKBUF_X1
X$3701 \$5988 VSS VDD \$I92185 CLKBUF_X1
X$3702 \$5415 VSS VDD \$5988 CLKBUF_X3
X$3703 VSS \$5988 \$I99899 \$6553 \$6369 \$6120 VDD DFFR_X1
X$3704 \$6554 VSS VDD \$6555 CLKBUF_X1
X$3705 \$6371 VSS VDD \$6556 CLKBUF_X1
X$3706 \$6372 VSS VDD \$6371 CLKBUF_X1
X$3707 \$6556 VSS VDD \$6426 CLKBUF_X1
X$3709 \$6373 VSS VDD \$5772 CLKBUF_X1
X$3710 \$6122 VSS VDD \$6123 CLKBUF_X1
X$3711 \$6123 VSS VDD \$6373 CLKBUF_X1
X$3712 \$5987 VSS VDD \$6374 CLKBUF_X1
X$3714 \$6215 VSS VDD \$6124 CLKBUF_X1
X$3715 \$6209 VSS VDD \$6192 CLKBUF_X1
X$3716 VSS \$5000 \$I100253 \$6185 \$6125 \$4734 VDD DFFR_X1
X$3717 \$6185 VSS VDD \$6127 CLKBUF_X1
X$3718 \$6417 VSS VDD \$5976 CLKBUF_X1
X$3723 \$6374 VSS VDD \$5936 CLKBUF_X1
X$3726 VSS \$6773 \$I100103 \$1764 \$6629 \$6120 VDD DFFR_X1
X$3729 \$6560 VSS VDD \$6418 CLKBUF_X1
X$3730 \$6377 VSS VDD \$6129 CLKBUF_X1
X$3731 \$6558 VSS VDD \$6624 CLKBUF_X1
X$3732 \$6624 VSS VDD \$6560 CLKBUF_X1
X$3733 \$6418 VSS VDD \$6417 CLKBUF_X1
X$3735 \$6814 VSS VDD \$6812 CLKBUF_X1
X$3736 \$6613 VSS VDD \$6407 CLKBUF_X1
X$3737 \$6610 VSS VDD \$6613 CLKBUF_X1
X$3738 \$6407 VSS VDD \$6131 CLKBUF_X1
X$3740 VSS \$5426 \$I100370 \$6132 \$6402 \$6120 VDD DFFR_X1
X$3741 \$6399 VSS VDD \$6147 CLKBUF_X1
X$3742 \$6147 VSS VDD \$6154 CLKBUF_X1
X$3744 VSS \$5426 \$I99855 \$6601 \$6606 \$6120 VDD DFFR_X1
X$3745 \$6601 VSS VDD \$6602 CLKBUF_X1
X$3746 \$6602 VSS VDD \$6600 CLKBUF_X1
X$3747 \$6600 VSS VDD \$6399 CLKBUF_X1
X$3748 \$6379 \$6563 VSS VDD \$6383 NAND2_X1
X$3749 \$6382 \$6129 \$5940 VDD VSS \$6140 AND3_X1
X$3750 \$6129 \$6380 \$6390 VDD VSS \$6388 AND3_X1
X$3752 \$6986 \$6381 VSS VDD \$6565 NAND2_X1
X$3753 \$6383 VSS VDD \$6382 INV_X1
X$3755 \$6565 VSS VDD \$6589 INV_X1
X$3756 \$6589 \$6382 \$6389 VDD VSS \$6566 HA_X1
X$3758 \$6140 \$6389 \$6390 VDD VSS \$6583 HA_X1
X$3769 \$6567 \$6583 VSS VDD \$6385 NAND2_X1
X$3770 \$6388 \$6568 \$6567 VDD VSS \$6586 HA_X1
X$3771 \$6586 VSS VDD \$6575 INV_X1
X$3772 \$6575 \$6385 VSS VDD \$6569 NAND2_X1
X$3785 \$9782 VSS VDD \$9789 CLKBUF_X1
X$3790 \$9362 VSS VDD \$9788 CLKBUF_X1
X$3791 \$9604 VSS VDD \$9544 CLKBUF_X1
X$3793 \$9788 VSS VDD \$9791 CLKBUF_X1
X$3794 \$9791 VSS VDD \$9363 CLKBUF_X1
X$3797 \$9931 VSS VDD \$9930 CLKBUF_X1
X$3798 \$9990 VSS VDD \$9991 CLKBUF_X1
X$3800 \$9930 VSS VDD \$10116 CLKBUF_X1
X$3802 \$10106 VSS VDD \$9922 CLKBUF_X1
X$3803 \$9789 VSS VDD \$9792 CLKBUF_X1
X$3805 \$9365 VSS VDD \$9793 CLKBUF_X1
X$3806 \$9793 VSS VDD \$9795 CLKBUF_X1
X$3807 \$9795 VSS VDD \$8638 CLKBUF_X1
X$3808 \$9366 VSS VDD \$9798 CLKBUF_X1
X$3809 \$9798 VSS VDD \$9528 CLKBUF_X1
X$3811 VSS \$9135 \$I100169 \$9607 \$9792 \$6763 VDD DFFR_X1
X$3812 \$9802 VSS VDD \$9297 CLKBUF_X1
X$3813 \$9138 VSS VDD \$9513 CLKBUF_X1
X$3816 \$9797 VSS VDD \$9836 CLKBUF_X1
X$3817 \$9927 VSS VDD \$9797 CLKBUF_X1
X$3819 \$9837 VSS VDD \$10095 CLKBUF_X1
X$3822 \$9838 VSS VDD \$9802 CLKBUF_X1
X$3823 \$9839 VSS VDD \$9838 CLKBUF_X1
X$3825 \$9920 VSS VDD \$9840 CLKBUF_X1
X$3826 \$9922 VSS VDD \$10076 CLKBUF_X1
X$3828 \$9607 VSS VDD \$9918 CLKBUF_X1
X$3829 \$9918 VSS VDD \$9917 CLKBUF_X1
X$3830 \$9917 VSS VDD \$9910 CLKBUF_X1
X$3831 VSS \$9781 \$I100524 \$9153 \$9145 \$8370 VDD DFFR_X1
X$3832 VSS \$9781 \$I100543 \$9780 \$9369 \$8370 VDD DFFR_X1
X$3833 \$9373 VSS VDD \$9277 CLKBUF_X1
X$3836 \$9841 VSS VDD \$9140 CLKBUF_X1
X$3837 \$9905 VSS VDD \$10083 CLKBUF_X1
X$3841 \$10080 VSS VDD \$9999 CLKBUF_X1
X$3842 \$9906 VSS VDD \$9509 CLKBUF_X1
X$3843 \$9910 VSS VDD \$9906 CLKBUF_X1
X$3844 \$9141 VSS VDD \$9016 CLKBUF_X1
X$3845 \$9018 VSS VDD \$9290 CLKBUF_X1
X$3846 \$9847 VSS VDD \$9146 CLKBUF_X1
X$3847 \$9780 VSS VDD \$9896 CLKBUF_X1
X$3848 \$9897 VSS VDD \$9611 CLKBUF_X1
X$3849 \$9896 VSS VDD \$9897 CLKBUF_X1
X$3852 \$9611 VSS VDD \$9500 CLKBUF_X1
X$3853 \$9893 VSS VDD \$9373 CLKBUF_X1
X$3854 \$9374 VSS VDD \$9766 CLKBUF_X1
X$3855 \$9766 VSS VDD \$9487 CLKBUF_X1
X$3856 \$9487 VSS VDD \$9484 CLKBUF_X1
X$3857 \$9375 VSS VDD \$9765 CLKBUF_X1
X$3858 \$9765 VSS VDD \$9764 CLKBUF_X1
X$3859 \$8782 VSS VDD \$9480 CLKBUF_X1
X$3862 VSS \$7618 \$I99862 \$9613 \$9764 \$8370 VDD DFFR_X1
X$3863 \$9613 VSS VDD \$9376 CLKBUF_X1
X$3864 \$9376 VSS VDD \$9378 CLKBUF_X1
X$3865 \$9378 VSS VDD \$9377 CLKBUF_X1
X$3866 \$9379 VSS VDD \$9888 CLKBUF_X1
X$3867 \$8370 VSS VDD \$6120 BUF_X2
X$3868 \$9749 VSS VDD \$9755 CLKBUF_X1
X$3871 VSS \$10005 \$I99986 \$8395 \$9755 \$6120 VDD DFFR_X1
X$3872 \$8395 VSS VDD \$9380 CLKBUF_X1
X$3873 \$9476 VSS VDD \$8923 CLKBUF_X1
X$3875 \$9381 VSS VDD \$9738 CLKBUF_X1
X$3876 \$9744 VSS VDD \$9381 CLKBUF_X1
X$3878 \$9888 VSS VDD \$9749 CLKBUF_X1
X$3879 \$9885 VSS VDD \$9886 CLKBUF_X1
X$3880 \$9886 VSS VDD \$9744 CLKBUF_X1
X$3882 \$9844 VSS VDD \$9736 CLKBUF_X1
X$3883 \$9464 VSS VDD \$9460 CLKBUF_X1
X$3884 VSS \$7875 \$9708 \$9385 \$9738 \$6120 VDD DFFR_X1
X$3886 \$6380 VSS VDD \$8392 CLKBUF_X1
X$3887 \$9385 VSS VDD \$9152 INV_X1
X$3888 VSS \$7875 \$I100511 \$6986 \$9716 \$6120 VDD DFFR_X1
X$3889 \$9847 \$6986 VSS VDD \$9617 NAND2_X1
X$3892 VSS \$7875 \$I99900 \$9881 \$9882 \$6120 VDD DFFR_X1
X$3894 \$9881 VSS VDD \$9880 CLKBUF_X1
X$3895 \$9880 VSS VDD \$9879 CLKBUF_X1
X$3896 \$9879 VSS VDD \$9877 CLKBUF_X1
X$3897 \$9877 VSS VDD \$9875 CLKBUF_X1
X$3898 \$9875 VSS VDD \$9868 CLKBUF_X1
X$3899 \$9868 VSS VDD \$9716 CLKBUF_X1
X$3901 \$9617 VSS VDD \$10453 INV_X1
X$3902 \$6379 VSS VDD \$9386 CLKBUF_X1
X$3904 VSS \$9617 \$10044 \$9858 \$9865 \$9708 VDD FA_X1
X$3906 \$8658 \$6379 VSS VDD \$9865 NAND2_X1
X$3908 VSS \$9389 \$9692 \$9688 \$9702 \$9390 VDD FA_X1
X$3909 \$9700 VSS VDD \$9390 INV_X1
X$3915 \$8395 \$6381 VSS VDD \$9700 NAND2_X1
X$3916 \$6987 \$8168 VSS VDD \$9620 NAND2_X1
X$3919 \$7869 \$6380 VSS VDD \$9618 NAND2_X1
X$3920 \$9618 VSS VDD \$9682 INV_X1
X$3921 VSS \$9395 \$10046 \$9621 \$9619 \$9682 VDD FA_X1
X$3922 VSS \$9429 \$9685 \$9659 \$9688 \$9621 VDD FA_X1
X$3923 \$9620 VSS VDD \$9619 INV_X1
X$3924 \$7877 \$6380 VSS VDD \$9664 NAND2_X1
X$3925 \$6381 \$8168 VSS VDD \$9622 NAND2_X1
X$3926 \$9622 VSS VDD \$9623 INV_X1
X$3928 \$9664 VSS VDD \$9410 INV_X1
X$3929 VSS \$9408 \$9624 \$9403 \$9623 \$9410 VDD FA_X1
X$3934 \$9644 VSS VDD \$9636 CLKBUF_X1
X$3935 \$9626 VSS VDD \$9644 CLKBUF_X1
X$3938 \$9645 VSS VDD \$9628 CLKBUF_X1
X$3940 \$9631 VSS VDD \$9629 INV_X1
X$3950 \$9858 VSS VDD \$9671 INV_X1
X$3952 VSS \$9671 \$10200 \$9855 \$9624 \$8692 VDD FA_X1
X$3953 VSS \$9653 \$10015 \$10037 \$9659 \$9855 VDD FA_X1
X$3956 VSS \$9627 \$I99882 \$9626 \$8172 \$9850 VDD DFFR_X1
X$3957 VSS \$9627 \$9645 \$9853 \$9398 \$9850 VDD DFFR_X1
X$3961 \$10204 VSS VDD \$10030 CLKBUF_X1
X$3962 \$9853 VSS VDD \$9852 CLKBUF_X1
X$3963 \$10020 VSS VDD \$9631 CLKBUF_X1
X$3973 \$17279 VSS VDD \$17682 CLKBUF_X1
X$3974 VSS \$17578 \$17680 \$17681 \$17575 \$17576 VDD FA_X1
X$3975 \$17573 VSS VDD \$17576 CLKBUF_X1
X$3990 \$17686 \$17694 VSS VDD \$17968 NAND2_X1
X$3991 \$17694 \$17853 \$16782 VSS VDD \$17856 NAND3_X1
X$3992 \$17682 \$17848 \$17969 VDD VSS \$17686 HA_X1
X$4009 \$18533 VSS VDD \$18743 CLKBUF_X1
X$4011 VSS \$18738 \$19164 \$18741 \$18607 \$18660 VDD FA_X1
X$4012 \$18741 VSS VDD \$18664 INV_X1
X$4013 VSS \$18609 \$18972 \$18682 \$18283 \$18664 VDD FA_X1
X$4016 \$18402 VSS VDD \$18782 INV_X1
X$4019 \$18608 VSS VDD \$18738 INV_X1
X$4022 \$18002 VSS VDD \$18742 INV_X1
X$4025 VSS \$18742 \$18965 \$18854 \$18851 \$17754 VDD FA_X1
X$4026 VSS \$18610 \$18783 \$18748 \$18682 \$18854 VDD FA_X1
X$4027 VSS \$18747 \$18683 \$18612 \$18748 \$18611 VDD FA_X1
X$4030 \$18785 VSS VDD \$18750 INV_X1
X$4034 \$18686 \$18286 \$18407 VSS \$18757 VDD AOI21_X1
X$4038 \$18683 VSS VDD \$18973 INV_X1
X$4039 \$18479 VSS VDD \$18871 CLKBUF_X1
X$4040 \$18734 \$18750 \$18684 VDD VSS \$18787 HA_X1
X$4041 \$18684 VSS VDD \$18751 CLKBUF_X1
X$4042 \$18787 \$18684 \$18366 VSS \$18786 VDD AOI21_X1
X$4044 \$18757 \$18787 VSS VDD \$19340 OR2_X1
X$4045 \$18751 VSS VDD \$18686 INV_X1
X$4047 \$18366 \$18870 VDD VSS \$18788 XNOR2_X1
X$4050 \$18687 VSS VDD \$18672 CLKBUF_X1
X$4052 \$18762 VSS VDD \$18687 CLKBUF_X1
X$4053 \$18484 VSS VDD \$18759 CLKBUF_X1
X$4054 \$18759 VSS VDD \$18673 CLKBUF_X1
X$4055 VSS \$18485 \$I100400 \$18690 \$18689 \$15541 VDD DFFR_X1
X$4059 \$18614 VSS VDD \$18762 CLKBUF_X1
X$4060 \$18672 VSS VDD \$18791 CLKBUF_X1
X$4061 \$18875 VSS VDD \$18689 CLKBUF_X1
X$4062 \$18791 VSS VDD \$18875 CLKBUF_X1
X$4066 \$18690 VSS VDD \$18877 CLKBUF_X1
X$4067 \$18877 VSS VDD \$18769 CLKBUF_X1
X$4069 \$18691 VSS VDD \$18489 INV_X1
X$4071 VSS \$18485 \$I100368 \$18696 \$18695 \$16907 VDD DFFR_X1
X$4073 VSS \$18485 \$18701 \$18494 \$18697 \$16907 VDD DFFR_X1
X$4074 \$18618 VSS VDD \$18617 INV_X1
X$4076 \$18693 \$18692 \$18490 VSS \$18793 VDD AOI21_X1
X$4077 \$18670 \$18693 VSS VDD \$18911 OR2_X1
X$4078 \$18769 VSS VDD \$18881 CLKBUF_X1
X$4079 \$18881 VSS VDD \$18772 CLKBUF_X1
X$4081 \$18772 VSS VDD \$18888 CLKBUF_X1
X$4083 \$18888 VSS VDD \$18695 CLKBUF_X1
X$4088 \$18696 VSS VDD \$18799 CLKBUF_X1
X$4089 \$18771 VSS VDD \$18895 CLKBUF_X1
X$4090 \$18799 VSS VDD \$18771 CLKBUF_X1
X$4091 \$18895 VSS VDD \$18800 CLKBUF_X1
X$4093 \$18893 VSS VDD \$18697 CLKBUF_X1
X$4094 \$18800 VSS VDD \$18893 CLKBUF_X1
X$4096 \$18884 VSS VDD \$18879 INV_X1
X$4097 \$15926 \$18708 VSS VDD \$18801 NAND2_X1
X$4099 \$18624 VSS VDD \$18699 CLKBUF_X1
X$4100 \$18765 VSS VDD \$18700 INV_X1
X$4104 VSS \$18654 \$18765 \$18593 \$18739 \$18702 VDD FA_X1
X$4108 VSS \$18803 \$18884 \$18702 \$18760 \$18619 VDD FA_X1
X$4110 \$18752 VSS VDD \$18620 INV_X1
X$4111 VSS \$18620 \$18760 \$18656 \$18753 \$18706 VDD FA_X1
X$4113 \$15506 \$18093 VSS VDD \$18705 NAND2_X1
X$4114 \$18705 VSS VDD \$18706 INV_X1
X$4117 \$18872 VSS VDD \$18753 INV_X1
X$4118 \$18052 \$17398 VSS VDD \$18872 NAND2_X1
X$4121 \$17010 \$17559 VSS VDD \$18752 NAND2_X1
X$4125 VSS \$18626 \$18873 \$18739 \$18867 \$19124 VDD FA_X1
X$4127 \$18701 \$16486 VSS VDD \$18746 NOR2_X1
X$4130 \$18708 VSS VDD \$18804 INV_X1
X$4133 \$18733 \$18154 \$18722 VDD \$18710 VSS OAI21_X1
X$4134 \$18627 VSS VDD \$18733 INV_X1
X$4135 \$18727 \$18627 VSS VDD \$18434 NAND2_X1
X$4137 \$18722 \$18712 \$18724 \$18434 \$18630 VDD VSS \$18637 OAI221_X1
X$4138 \$18711 VSS VDD \$18724 INV_X1
X$4142 \$18632 \$18717 VDD VSS \$18634 XNOR2_X1
X$4143 \$18633 \$18636 \$17411 VSS VDD NOR2_X4
X$4158 \$18627 VSS VDD \$18735 CLKBUF_X1
X$4160 \$18807 \$18628 \$18627 VDD VSS \$18852 HA_X1
X$4161 \$18852 VSS VDD \$18722 INV_X1
X$4162 \$18727 VSS VDD \$18712 INV_X1
X$4166 \$18843 VSS VDD \$18807 CLKBUF_X1
X$4168 VSS \$18501 \$18811 \$18833 \$14664 \$16907 VDD DFFR_X1
X$4170 \$18826 \$18812 VSS VDD \$18831 XOR2_X1
X$4171 \$18831 VSS VDD \$18813 CLKBUF_X1
X$4173 \$18713 VSS VDD \$18961 CLKBUF_X1
X$4179 \$18636 \$18827 \$18507 VSS \$18828 VDD AOI21_X1
X$4180 \$18633 VSS VDD \$18827 INV_X1
X$4182 \$18818 \$18636 VSS VDD \$18826 NOR2_X1
X$4207 VSS \$1593 \$I100508 \$2195 \$2478 \$1304 VDD DFFR_X1
X$4208 \$1913 VSS VDD \$2038 CLKBUF_X1
X$4209 \$1692 VSS VDD \$1593 CLKBUF_X3
X$4211 \$2781 VSS VDD \$2780 CLKBUF_X1
X$4212 \$2481 VSS VDD \$2446 CLKBUF_X1
X$4213 \$2483 VSS VDD \$2336 CLKBUF_X1
X$4214 \$2484 VSS VDD \$2483 CLKBUF_X1
X$4215 \$2336 VSS VDD \$2481 CLKBUF_X1
X$4216 \$1597 VSS VDD \$2116 CLKBUF_X1
X$4217 VSS \$1696 \$I100364 \$2392 \$2487 \$1304 VDD DFFR_X1
X$4219 \$2770 VSS VDD \$2478 CLKBUF_X1
X$4220 \$2617 VSS VDD \$2895 CLKBUF_X1
X$4221 \$2898 VSS VDD \$2619 CLKBUF_X1
X$4225 \$2725 VSS VDD \$2617 CLKBUF_X1
X$4226 VSS \$1593 \$I99851 \$2782 \$2619 \$1304 VDD DFFR_X1
X$4227 \$2626 VSS VDD \$2487 CLKBUF_X1
X$4228 \$2446 VSS VDD \$2626 CLKBUF_X1
X$4229 \$2727 VSS VDD \$2786 CLKBUF_X1
X$4230 \$2629 VSS VDD \$2728 CLKBUF_X1
X$4231 \$2392 VSS VDD \$2387 CLKBUF_X1
X$4232 \$2729 VSS VDD \$2787 CLKBUF_X1
X$4233 \$2391 VSS VDD \$2629 CLKBUF_X1
X$4234 \$1692 VSS VDD \$1696 CLKBUF_X3
X$4235 VSS \$1696 \$I99873 \$2731 \$2787 \$1304 VDD DFFR_X1
X$4236 VSS \$1696 \$I100385 \$2448 \$2042 \$1304 VDD DFFR_X1
X$4237 \$2492 VSS VDD \$2338 CLKBUF_X1
X$4238 \$2493 VSS VDD \$2199 CLKBUF_X1
X$4239 \$2448 VSS VDD \$2266 CLKBUF_X1
X$4245 VSS \$2862 \$I99890 \$2803 \$2339 \$1304 VDD DFFR_X1
X$4246 \$2641 VSS VDD \$2734 CLKBUF_X1
X$4247 \$2340 VSS VDD \$2642 CLKBUF_X1
X$4248 \$2642 VSS VDD \$2493 CLKBUF_X1
X$4254 \$2738 \$1869 VSS VDD \$2644 XOR2_X1
X$4255 \$2579 \$2811 \$2449 VDD \$2738 VSS OAI21_X1
X$4257 \$2449 \$2649 VSS VDD \$2043 NAND2_X1
X$4259 \$2500 VSS VDD \$2449 INV_X1
X$4262 \$2505 VSS VDD \$2657 INV_X1
X$4266 \$2507 VSS VDD \$2400 INV_X1
X$4268 VSS \$2523 \$2342 \$2665 \$2509 \$2663 VDD FA_X1
X$4269 \$1009 \$759 VSS VDD \$2663 NOR2_X1
X$4270 \$1872 \$428 VSS VDD \$2743 NOR2_X1
X$4273 \$1209 \$2834 \$428 \$25 VSS VDD \$2408 NOR4_X1
X$4274 \$2454 \$428 VSS VDD \$2410 NOR2_X1
X$4275 \$1872 \$1706 VSS VDD \$2523 NOR2_X1
X$4276 \$2454 \$527 VSS VDD \$2509 NOR2_X1
X$4278 \$2050 \$527 VSS VDD \$2415 NOR2_X1
X$4281 \$2536 \$33 VSS VDD \$1347 NAND2_X1
X$4285 \$2200 \$2580 VSS VDD \$2649 NAND2_X1
X$4286 \$2740 \$2579 \$2449 VDD \$2581 VSS OAI21_X1
X$4288 \$2200 VSS VDD \$2579 INV_X1
X$4290 \$2656 \$2818 \$2647 VDD VSS \$2945 HA_X1
X$4292 \$2502 VSS VDD \$2818 INV_X1
X$4296 VSS \$2741 \$2656 \$2822 \$2657 \$2823 VDD FA_X1
X$4299 \$2665 \$2839 \$2825 VDD VSS \$2507 HA_X1
X$4300 \$2407 \$577 \$2742 VDD VSS \$2830 HA_X1
X$4302 \$1009 \$25 VSS VDD \$3095 NOR2_X1
X$4304 \$1209 \$759 VSS VDD \$2744 NOR2_X1
X$4308 \$1872 \$759 VSS VDD \$2956 NOR2_X1
X$4309 \$1872 \$25 VSS VDD \$2745 NOR2_X1
X$4310 \$2454 \$1706 VSS VDD \$2746 NOR2_X1
X$4311 \$2536 \$1706 VSS VDD \$3400 NOR2_X1
X$4313 \$2536 \$1707 VSS VDD \$2839 NOR2_X1
X$4316 VSS \$2313 \$2454 \$1160 \$2844 \$45 VDD DFFR_X1
X$4321 \$2344 \$2586 \$2587 VSS VDD \$527 NAND3_X1
X$4322 \$583 \$2588 VSS VDD \$926 NAND2_X1
X$4325 \$2748 \$2344 VSS VDD \$428 NAND2_X1
X$4327 \$1068 \$2588 VSS VDD \$2589 NAND2_X1
X$4329 \$2205 VSS VDD \$3014 CLKBUF_X1
X$4330 \$1349 VSS VDD \$2425 CLKBUF_X1
X$4331 \$2701 VSS VDD \$2562 CLKBUF_X1
X$4332 \$3266 VSS VDD \$38 CLKBUF_X1
X$4333 \$2564 VSS VDD \$2208 CLKBUF_X1
X$4334 \$2562 VSS VDD \$2053 CLKBUF_X1
X$4335 \$2209 VSS VDD \$2564 CLKBUF_X1
X$4337 \$2461 VSS VDD \$2702 CLKBUF_X1
X$4340 \$2569 VSS VDD \$2211 CLKBUF_X1
X$4342 \$2702 VSS VDD \$2315 CLKBUF_X1
X$4343 \$922 VSS VDD \$2701 CLKBUF_X1
X$4347 \$2709 VSS VDD \$2711 CLKBUF_X1
X$4348 \$2711 VSS VDD \$2749 CLKBUF_X1
X$4349 \$2591 VSS VDD \$3444 CLKBUF_X1
X$4350 \$2749 VSS VDD \$2591 CLKBUF_X1
X$4351 \$2713 VSS VDD \$2854 CLKBUF_X1
X$4352 \$1877 VSS VDD \$2750 CLKBUF_X1
X$4353 \$2570 VSS VDD \$2569 CLKBUF_X1
X$4356 \$2462 VSS VDD \$2570 CLKBUF_X1
X$4362 \$2567 VSS VDD \$2318 CLKBUF_X1
X$4366 \$2563 \$2443 \$1718 VDD VSS \$1719 HA_X1
X$4367 \$2439 VSS VDD \$2567 CLKBUF_X1
X$4368 \$2753 VSS VDD \$2443 INV_X1
X$4369 \$2560 VSS VDD \$2563 INV_X1
X$4374 \$2179 VSS VDD \$2752 CLKBUF_X1
X$4375 VSS \$2592 \$2751 \$3735 \$2558 \$2850 VDD FA_X1
X$4376 \$2723 VSS VDD \$2592 INV_X1
X$4379 \$2756 \$458 VSS VDD \$2020 NAND2_X1
X$4380 \$2882 VSS VDD \$1884 CLKBUF_X1
X$4381 \$2555 VSS VDD \$2327 CLKBUF_X1
X$4384 \$2551 VSS VDD \$2555 CLKBUF_X1
X$4385 \$2463 VSS VDD \$2350 INV_X1
X$4386 \$2058 \$2359 VSS VDD \$2553 NOR2_X1
X$4388 \$2546 VSS VDD \$2551 CLKBUF_X1
X$4389 VSS \$2215 \$2545 \$1611 \$2544 \$327 VDD DFFR_X1
X$4391 \$2545 VSS VDD \$2057 INV_X1
X$4395 \$397 \$395 \$2355 VDD VSS \$2359 AND3_X1
X$4396 \$2357 VSS VDD \$2319 CLKBUF_X1
X$4398 VSS \$2835 \$2723 \$3466 \$2719 \$2836 VDD FA_X1
X$4400 \$727 \$2359 VSS VDD \$2593 NAND2_X1
X$4401 \$2593 VSS VDD \$2967 INV_X1
X$4403 \$2058 \$2759 VSS VDD \$2758 NOR2_X1
X$4404 \$2827 VSS VDD \$2829 INV_X1
X$4406 \$726 \$2184 VSS VDD \$2827 NAND2_X1
X$4408 \$1611 VSS VDD \$2183 CLKBUF_X1
X$4409 \$2706 VSS VDD \$2322 CLKBUF_X1
X$4410 \$2821 VSS VDD \$2712 CLKBUF_X1
X$4413 \$2817 \$2184 \$2530 VDD VSS \$2358 HA_X1
X$4414 \$2530 VSS VDD \$2061 CLKBUF_X1
X$4417 VSS \$1720 \$I100252 \$2464 \$2365 \$327 VDD DFFR_X1
X$4418 \$2512 \$2359 \$2158 VDD VSS \$2305 HA_X1
X$4419 \$2464 \$2363 VSS VDD \$1659 NOR2_X1
X$4421 \$2364 VSS VDD \$2301 CLKBUF_X1
X$4422 \$2363 \$395 \$397 VSS VDD \$2466 NAND3_X1
X$4424 \$2070 VSS VDD \$2404 CLKBUF_X1
X$4425 \$2395 VSS VDD \$2365 CLKBUF_X1
X$4427 \$2503 \$2070 VSS VDD \$2069 NAND2_X1
X$4428 \$2503 VSS VDD \$2366 INV_X1
X$4433 \$2497 \$2468 \$2227 VDD \$2603 VSS OAI21_X1
X$4434 \$2076 VSS VDD \$2497 INV_X1
X$4437 \$2813 VSS VDD \$2008 CLKBUF_X1
X$4438 \$2692 VSS VDD \$2360 CLKBUF_X1
X$4439 \$2464 \$395 \$397 VSS VDD \$3030 NAND3_X1
X$4444 \$2682 \$2759 \$2070 VDD VSS \$2068 HA_X1
X$4448 \$2466 VSS VDD \$2759 INV_X1
X$4452 \$2808 VSS VDD \$2682 CLKBUF_X1
X$4453 \$2071 VSS VDD \$2224 CLKBUF_X1
X$4460 \$1727 VSS VDD \$I68362 INV_X1
X$4461 \$2797 VSS VDD \$2923 CLKBUF_X1
X$4462 \$750 VSS VDD \$1727 CLKBUF_X3
X$4463 VSS \$1727 \$I99845 \$2797 \$2798 \$327 VDD DFFR_X1
X$4466 \$2468 \$2076 VDD VSS \$2798 XNOR2_X1
X$4467 \$2648 \$2793 \$2076 VDD VSS \$2470 HA_X1
X$4469 \$2470 VSS VDD \$2227 INV_X1
X$4471 \$2606 \$1901 VSS VDD \$2472 NAND2_X1
X$4472 \$2472 VSS VDD \$2370 INV_X1
X$4478 \$2371 \$1764 VSS VDD \$2605 NAND2_X1
X$4479 \$2605 VSS VDD \$2646 INV_X1
X$4481 VSS \$2789 \$2765 \$3064 \$2646 \$2370 VDD FA_X1
X$4483 \$2606 \$2083 VSS VDD \$2608 NAND2_X1
X$4485 \$2608 VSS VDD \$2639 INV_X1
X$4486 \$2639 \$2766 \$1734 VDD VSS \$2779 HA_X1
X$4487 \$2609 \$2083 VSS VDD \$2231 NAND2_X1
X$4491 VSS \$2372 \$2390 \$2119 \$3051 \$2611 VDD FA_X1
X$4492 \$2485 VSS VDD \$2372 INV_X1
X$4493 VSS \$2776 \$2485 \$2122 \$3190 \$2474 VDD FA_X1
X$4495 \$2767 VSS VDD \$2766 INV_X1
X$4496 \$2609 \$2084 VSS VDD \$2767 NAND2_X1
X$4499 \$2637 VSS VDD \$2611 INV_X1
X$4500 VSS \$2778 \$2637 \$2474 \$2635 \$2779 VDD FA_X1
X$4501 VSS \$2625 \$2635 \$2907 \$2627 \$2772 VDD FA_X1
X$4502 \$1902 \$1764 VSS VDD \$2476 NAND2_X1
X$4514 \$2476 VSS VDD \$2627 INV_X1
X$4515 \$2773 VSS VDD \$2625 INV_X1
X$4516 \$1904 \$1743 VSS VDD \$2773 NAND2_X1
X$4517 \$2371 \$1901 VSS VDD \$2615 NAND2_X1
X$4518 \$2615 VSS VDD \$2772 INV_X1
X$4533 VSS \$16449 \$I100459 \$16450 \$16310 \$15672 VDD DFFR_X1
X$4534 xin[6] VSS VDD \$16310 BUF_X1
X$4536 VSS \$16449 \$I100374 \$12450 \$16451 \$15672 VDD DFFR_X1
X$4537 \$16375 \$16372 \$16643 VDD VSS \$16518 HA_X1
X$4549 \$16450 VSS VDD \$16708 CLKBUF_X1
X$4550 \$16708 VSS VDD \$16515 CLKBUF_X1
X$4551 \$16710 VSS VDD \$16452 CLKBUF_X1
X$4552 \$16714 VSS VDD \$16451 CLKBUF_X1
X$4553 \$16452 VSS VDD \$16714 CLKBUF_X1
X$4554 \$16515 VSS VDD \$16710 CLKBUF_X1
X$4557 \$16641 VSS VDD \$13710 INV_X1
X$4559 \$16518 VSS VDD \$16458 INV_X1
X$4560 \$12450 VSS VDD \$16720 CLKBUF_X1
X$4561 \$16720 VSS VDD \$16725 CLKBUF_X1
X$4562 \$16108 \$16643 VSS VDD \$16454 NAND2_X1
X$4564 \$16109 \$16311 \$16455 VDD VSS \$16459 HA_X1
X$4567 \$16454 VSS VDD \$16731 INV_X1
X$4568 \$16455 \$16731 VSS VDD \$16525 NAND2_X1
X$4569 \$16728 \$16731 \$16385 VSS \$16457 VDD AOI21_X1
X$4570 \$16458 \$16646 \$16457 \$16525 \$16537 VDD VSS \$16648 OAI221_X1
X$4571 \$16312 \$16313 \$16539 VDD \$16385 VSS OAI21_X1
X$4572 \$16459 VSS VDD \$16539 INV_X1
X$4573 \$16390 VSS VDD \$16312 INV_X1
X$4575 \$16389 \$15897 VSS VDD \$16537 NAND2_X1
X$4576 \$15897 \$16389 VSS VDD \$17375 XOR2_X1
X$4577 \$13131 \$16394 VDD VSS \$16547 XNOR2_X1
X$4578 \$16860 \$15247 VSS VDD \$16394 NAND2_X1
X$4581 \$16455 VSS VDD \$16313 INV_X1
X$4582 \$16312 \$16537 VSS VDD \$16649 NAND2_X1
X$4585 \$15672 VSS VDD \$12319 BUF_X2
X$4586 \$16547 \$16648 VDD VSS \$17542 XNOR2_X1
X$4588 VSS \$16461 \$I100183 \$16460 \$17049 \$12319 VDD DFFR_X1
X$4590 VSS \$16461 \$I100366 \$16559 \$16315 \$12319 VDD DFFR_X1
X$4591 VSS \$16461 \$I100466 \$16318 \$16317 \$15672 VDD DFFR_X1
X$4595 \$16460 VSS VDD \$16760 CLKBUF_X1
X$4596 \$16760 VSS VDD \$16762 CLKBUF_X1
X$4597 \$16556 VSS VDD \$16766 CLKBUF_X1
X$4598 \$16767 VSS VDD \$16556 CLKBUF_X1
X$4599 \$16766 VSS VDD \$16315 CLKBUF_X1
X$4601 \$16559 VSS VDD \$16462 CLKBUF_X1
X$4602 \$16772 VSS VDD \$16463 CLKBUF_X1
X$4603 \$16462 VSS VDD \$16772 CLKBUF_X1
X$4604 \$16561 VSS VDD \$16465 CLKBUF_X1
X$4605 \$16463 VSS VDD \$16561 CLKBUF_X1
X$4606 \$16465 VSS VDD \$16317 CLKBUF_X1
X$4608 \$16112 VSS VDD \$16113 CLKBUF_X1
X$4609 \$16114 VSS VDD \$16780 CLKBUF_X1
X$4610 \$16784 VSS VDD \$16567 CLKBUF_X1
X$4611 \$13150 VSS VDD \$16319 CLKBUF_X3
X$4613 VSS \$16319 \$I100530 \$15388 \$16567 \$15672 VDD DFFR_X1
X$4614 VSS \$16319 \$I100120 \$17174 \$16111 \$12319 VDD DFFR_X1
X$4616 \$16413 VSS VDD \$15902 CLKBUF_X1
X$4617 \$16412 VSS VDD \$16579 CLKBUF_X1
X$4618 \$16579 VSS VDD \$16413 CLKBUF_X1
X$4619 \$16115 VSS VDD \$16583 CLKBUF_X1
X$4620 \$16583 VSS VDD \$16200 CLKBUF_X1
X$4622 \$16873 VSS VDD \$16793 CLKBUF_X1
X$4623 VSS \$16319 \$I100135 \$16661 \$16468 \$12319 VDD DFFR_X1
X$4625 \$15388 VSS VDD \$16419 CLKBUF_X1
X$4630 VSS \$16803 \$16605 \$16820 \$16809 \$16118 VDD FA_X1
X$4631 \$16592 VSS VDD \$16809 INV_X1
X$4633 VSS \$16602 \$16592 \$16427 \$16594 \$16322 VDD FA_X1
X$4634 \$16323 \$13178 VSS VDD \$16602 NAND2_X1
X$4637 \$16472 VSS VDD \$16325 INV_X1
X$4643 \$16469 \$13181 VSS VDD \$16594 NAND2_X1
X$4648 \$16882 \$16820 \$16472 VDD VSS \$16664 HA_X1
X$4655 \$16471 VSS VDD \$16825 INV_X1
X$4656 \$16825 \$16824 \$16665 VDD VSS \$17016 HA_X1
X$4658 \$16326 \$16665 VDD VSS \$16473 XNOR2_X1
X$4659 \$16473 VSS VDD \$16832 INV_X1
X$4660 \$16665 \$16326 VSS VDD \$16828 NAND2_X1
X$4662 \$16613 VSS VDD \$16328 CLKBUF_X1
X$4664 \$15541 VDD \$15181 VSS BUF_X4
X$4665 VSS \$17041 \$I100232 \$16623 \$16330 \$15181 VDD DFFR_X1
X$4666 \$16618 VSS VDD \$16127 CLKBUF_X1
X$4667 \$16476 VSS VDD \$16627 CLKBUF_X1
X$4668 \$16627 VSS VDD \$16250 CLKBUF_X1
X$4669 \$16331 VSS VDD \$16625 CLKBUF_X1
X$4670 \$16516 VSS VDD \$15668 INV_X1
X$4671 \$16443 VSS VDD \$16630 CLKBUF_X1
X$4673 \$16630 VSS VDD \$16632 CLKBUF_X1
X$4674 \$16631 VSS VDD \$15699 INV_X1
X$4676 \$16632 VSS VDD \$16133 CLKBUF_X1
X$4677 \$16332 VSS VDD \$15695 INV_X1
X$4679 \$16437 VSS VDD \$16637 CLKBUF_X1
X$4680 \$16637 VSS VDD \$16334 CLKBUF_X1
X$4681 \$16850 VSS VDD \$16333 CLKBUF_X1
X$4685 \$16137 VSS VDD \$15922 CLKBUF_X1
X$4686 \$16478 VSS VDD \$16636 CLKBUF_X1
X$4687 \$16633 VSS VDD \$16638 CLKBUF_X1
X$4688 \$16638 VSS VDD \$16336 CLKBUF_X1
X$4689 \$16636 VSS VDD \$16633 CLKBUF_X1
X$4694 \$16474 VSS VDD \$16613 CLKBUF_X1
X$4698 \$16625 VSS VDD \$16475 CLKBUF_X1
X$4699 \$16839 VSS VDD \$16844 CLKBUF_X1
X$4700 \$16844 VSS VDD \$16615 CLKBUF_X1
X$4702 \$16846 VSS VDD \$16476 CLKBUF_X1
X$4703 \$16624 VSS VDD \$16846 CLKBUF_X1
X$4704 \$16623 VSS VDD \$16624 CLKBUF_X1
X$4707 \$16848 \$16398 \$15916 VDD VSS \$16631 HA_X1
X$4710 \$17254 \$16851 \$16134 VDD VSS \$15700 HA_X1
X$4714 \$16548 VSS VDD \$16851 INV_X1
X$4718 \$16335 VSS VDD \$16478 CLKBUF_X1
X$4721 \$16626 VSS VDD \$16620 CLKBUF_X1
X$4722 \$16337 VSS VDD \$16626 CLKBUF_X1
X$4723 \$16140 VSS VDD \$16616 CLKBUF_X1
X$4724 \$16616 VSS VDD \$16338 CLKBUF_X1
X$4725 \$16620 VSS VDD \$16138 CLKBUF_X1
X$4727 \$16339 VSS VDD \$16483 INV_X1
X$4728 \$16606 \$15506 \$16486 VSS VDD \$16339 NAND3_X1
X$4730 \$16856 VSS VDD \$16857 INV_X1
X$4731 \$16857 \$16621 VSS VDD \$16673 NAND2_X1
X$4732 \$16480 VSS VDD \$15927 CLKBUF_X1
X$4733 \$16482 \$16610 VSS VDD \$16621 NAND2_X1
X$4734 \$16483 \$16894 \$16482 VDD VSS \$16856 HA_X1
X$4735 \$16845 \$16849 \$16606 VDD VSS \$16610 HA_X1
X$4736 \$16609 VSS VDD \$16341 CLKBUF_X1
X$4737 \$16601 VSS VDD \$16609 CLKBUF_X1
X$4738 \$16340 VSS VDD \$16601 CLKBUF_X1
X$4742 \$16835 VSS VDD \$16421 CLKBUF_X1
X$4745 VSS \$16489 \$I100481 \$16818 \$16596 \$15181 VDD DFFR_X1
X$4746 \$16590 VSS VDD \$16587 CLKBUF_X1
X$4747 VSS \$16489 \$I100269 \$16581 \$16684 \$15181 VDD DFFR_X1
X$4748 VSS \$16572 \$I100311 \$14700 \$16580 \$15181 VDD DFFR_X1
X$4750 VSS \$16572 \$I100395 \$16492 \$16569 \$15181 VDD DFFR_X1
X$4751 \$16493 VSS VDD \$16564 CLKBUF_X1
X$4752 \$16563 VSS VDD \$16566 CLKBUF_X1
X$4754 \$16566 VSS VDD \$16347 CLKBUF_X1
X$4755 \$16564 VSS VDD \$16563 CLKBUF_X1
X$4757 \$16485 \$16672 \$16486 VDD VSS \$16845 AND3_X1
X$4759 \$16487 VSS VDD \$16485 INV_X1
X$4761 \$16335 \$16677 VSS VDD \$16487 NAND2_X1
X$4764 VSS \$16489 \$I99974 \$16993 \$16488 \$15181 VDD DFFR_X1
X$4765 VSS \$16489 \$I99942 \$16683 \$16681 \$15181 VDD DFFR_X1
X$4766 \$16818 VSS VDD \$16590 CLKBUF_X1
X$4767 \$16816 VSS VDD \$16686 CLKBUF_X1
X$4769 \$16813 VSS VDD \$16576 CLKBUF_X1
X$4770 \$16587 VSS VDD \$16813 CLKBUF_X1
X$4772 \$16808 VSS VDD \$16574 CLKBUF_X1
X$4773 \$16345 VSS VDD \$16289 CLKBUF_X1
X$4774 \$16576 VSS VDD \$16808 CLKBUF_X1
X$4775 \$16581 VSS VDD \$16977 CLKBUF_X1
X$4776 \$16800 VSS VDD \$16580 CLKBUF_X1
X$4777 \$16804 VSS VDD \$16796 CLKBUF_X1
X$4778 \$16795 VSS VDD \$16800 CLKBUF_X1
X$4780 \$16688 VSS VDD \$16569 CLKBUF_X1
X$4787 \$16492 VSS VDD \$16493 CLKBUF_X1
X$4790 \$15197 VSS VDD \$17096 CLKBUF_X1
X$4794 VSS \$15933 \$I99810 \$16791 \$14270 \$15181 VDD DFFR_X1
X$4795 \$15716 VSS VDD \$16408 CLKBUF_X1
X$4796 \$16348 VSS VDD \$15566 CLKBUF_X1
X$4798 \$15560 VSS VDD \$15933 CLKBUF_X3
X$4803 VSS \$15933 \$I99904 \$16785 \$13840 \$15181 VDD DFFR_X1
X$4804 \$16156 VSS VDD \$15939 CLKBUF_X1
X$4806 \$16349 VSS VDD \$15938 CLKBUF_X1
X$4810 \$16551 \$16403 VDD VSS \$16404 XNOR2_X1
X$4811 \$16785 VSS VDD \$16965 CLKBUF_X1
X$4812 \$14038 VSS VDD \$16691 INV_X1
X$4815 \$16350 VSS VDD \$16403 INV_X1
X$4816 \$16352 \$16399 \$16350 VDD VSS \$16351 HA_X1
X$4817 \$16350 \$16551 VSS VDD \$16158 NAND2_X1
X$4818 \$16552 VSS VDD \$16352 INV_X1
X$4820 VSS \$16259 \$16693 \$16764 \$16541 \$13844 VDD FA_X1
X$4821 \$16531 VSS VDD \$16533 INV_X1
X$4825 VSS \$16545 \$16552 \$16958 \$15945 \$16773 VDD FA_X1
X$4827 VSS \$16353 \$16773 \$16769 \$16533 \$16693 VDD FA_X1
X$4828 VSS \$16498 \$16545 \$16694 \$16534 \$16769 VDD FA_X1
X$4830 \$16527 VSS VDD \$16498 INV_X1
X$4831 \$14700 \$13872 VSS VDD \$16499 NAND2_X1
X$4833 \$16499 VSS VDD \$16164 INV_X1
X$4835 VSS \$16523 \$16527 \$16501 \$15720 \$16395 VDD FA_X1
X$4836 \$16356 \$16387 \$16521 VDD VSS \$16523 HA_X1
X$4839 \$16519 VSS VDD \$16504 INV_X1
X$4842 \$16358 \$16357 \$16741 VDD VSS \$16505 HA_X1
X$4847 \$16764 VSS VDD \$16957 INV_X1
X$4851 \$16500 VSS VDD \$16697 INV_X1
X$4852 \$16503 VSS VDD \$16696 INV_X1
X$4855 \$16172 \$16504 \$16946 VDD VSS \$16743 HA_X1
X$4860 \$16506 \$16698 \$16730 VDD VSS \$16734 HA_X1
X$4861 \$16359 VSS VDD \$16506 INV_X1
X$4862 \$16171 VSS VDD \$16698 INV_X1
X$4863 \$16360 \$16383 \$16377 VDD VSS \$16507 HA_X1
X$4870 \$16717 VSS VDD \$16713 INV_X1
X$4872 VSS \$16514 \$16704 \$16362 \$16361 \$16176 VDD FA_X1
X$4874 \$16508 \$16362 \$16510 VSS VDD \$16509 NAND3_X1
X$4882 \$16366 VSS VDD \$16706 INV_X1
X$4883 \$16704 \$16701 \$16508 VDD VSS \$16702 HA_X1
X$4896 VSS \$9560 \$I100457 \$11118 \$11359 \$8875 VDD DFFR_X1
X$4897 \$11112 VSS VDD \$10868 CLKBUF_X1
X$4898 \$11116 VSS VDD \$11031 CLKBUF_X1
X$4899 \$10883 VSS VDD \$11116 CLKBUF_X1
X$4900 \$10882 VSS VDD \$10878 CLKBUF_X1
X$4901 \$11120 VSS VDD \$10884 CLKBUF_X1
X$4902 \$11033 VSS VDD \$10883 CLKBUF_X1
X$4904 \$11127 VSS VDD \$11129 INV_X1
X$4905 \$11129 \$11036 \$11038 \$10232 \$10532 VDD VSS \$10536 OAI221_X1
X$4906 \$11134 \$10790 \$11129 VDD \$11412 VSS OAI21_X1
X$4914 dxin[7] VSS VDD \$11029 BUF_X1
X$4920 VSS \$11109 \$I100086 \$11301 \$11408 \$8875 VDD DFFR_X1
X$4921 \$11030 VSS VDD \$11362 CLKBUF_X1
X$4922 \$11365 VSS VDD \$11112 CLKBUF_X1
X$4923 \$11115 VSS VDD \$11117 CLKBUF_X1
X$4924 \$11117 VSS VDD \$11302 CLKBUF_X1
X$4925 \$11118 VSS VDD \$11115 CLKBUF_X1
X$4927 \$10529 VSS VDD \$10626 CLKBUF_X1
X$4928 \$10365 VSS VDD \$11033 CLKBUF_X1
X$4931 \$11034 \$11303 \$10788 VDD VSS \$11127 HA_X1
X$4932 \$11037 \$10788 VSS VDD \$10232 NAND2_X1
X$4933 \$10788 VSS VDD \$11134 INV_X1
X$4936 \$10632 VSS VDD \$11136 CLKBUF_X1
X$4937 \$10791 VSS VDD \$10904 CLKBUF_X1
X$4938 VSS \$9099 \$I100406 \$10913 \$11136 \$8875 VDD DFFR_X1
X$4942 \$10913 \$7826 VSS VDD \$11040 NAND2_X1
X$4944 \$11040 VSS VDD \$11303 INV_X1
X$4950 \$11147 VSS VDD \$11306 INV_X1
X$4951 \$11149 \$10794 VSS VDD \$11147 NAND2_X1
X$4952 \$11151 VSS VDD \$11150 CLKBUF_X1
X$4953 \$11042 VSS VDD \$10165 CLKBUF_X1
X$4957 VSS \$10923 \$11043 \$11155 \$10797 \$10546 VDD FA_X1
X$4960 VSS \$11428 \$10546 \$9966 \$11049 \$10799 VDD FA_X1
X$4963 VSS \$11163 \$11044 \$10937 \$10802 \$10801 VDD FA_X1
X$4964 \$10802 VSS VDD \$10928 INV_X1
X$4966 \$8535 \$8627 VSS VDD \$10801 NAND2_X1
X$4968 VSS \$11751 \$11310 \$11151 \$1662 \$8875 VDD DFFR_X1
X$4971 \$10544 VSS VDD \$11388 INV_X1
X$4975 \$11159 VSS VDD \$11311 INV_X1
X$4979 \$11044 VSS VDD \$11390 INV_X1
X$4983 \$7339 \$9122 VSS VDD \$11046 NAND2_X1
X$4985 \$11046 VSS VDD \$11525 INV_X1
X$4986 \$11312 VSS VDD \$11429 INV_X1
X$4987 \$8897 \$8627 VSS VDD \$11312 NAND2_X1
X$4990 \$8535 \$9580 VSS VDD \$10802 NAND2_X1
X$4991 \$11173 \$10955 \$11049 VDD VSS \$11428 HA_X1
X$4992 \$10809 VSS VDD \$11173 INV_X1
X$4994 \$8535 \$722 VSS VDD \$10809 NAND2_X1
X$4996 \$8897 \$722 VSS VDD \$11176 NAND2_X1
X$4998 \$11051 VSS VDD \$10955 INV_X1
X$4999 \$8535 \$6759 VSS VDD \$11051 NAND2_X1
X$5008 VSS \$11051 \$11314 \$11315 \$11176 \$9579 VDD FA_X1
X$5011 \$7339 \$722 VSS VDD \$11053 NAND2_X1
X$5013 \$11053 VSS VDD \$11399 INV_X1
X$5014 \$8897 \$6759 VSS VDD \$11057 NAND2_X1
X$5015 \$11057 VSS VDD \$11318 INV_X1
X$5016 VSS \$10813 \$11185 \$11058 \$11186 \$11187 VDD FA_X1
X$5021 \$11189 VSS VDD \$11187 INV_X1
X$5025 \$7785 \$722 VSS VDD \$11319 NAND2_X1
X$5026 \$7339 \$6759 VSS VDD \$11060 NAND2_X1
X$5028 \$6756 \$8627 VSS VDD \$10563 NAND2_X1
X$5030 \$11060 VSS VDD \$11320 INV_X1
X$5034 \$8629 \$722 VSS VDD \$11576 NAND2_X1
X$5035 \$7785 \$6759 VSS VDD \$11321 NAND2_X1
X$5036 VSS \$11206 \$11322 \$11404 \$11207 \$11323 VDD FA_X1
X$5037 \$6756 \$9580 VSS VDD \$11064 NAND2_X1
X$5039 \$11066 VSS VDD \$10984 CLKBUF_X1
X$5040 \$7846 \$8627 VSS VDD \$11065 NAND2_X1
X$5041 \$11065 VSS VDD \$11206 INV_X1
X$5043 \$8269 \$9122 VSS VDD \$11216 NAND2_X1
X$5046 \$9580 \$7846 VSS VDD \$11068 NAND2_X1
X$5047 \$11438 VSS VDD \$10997 CLKBUF_X1
X$5049 \$10566 VSS VDD \$11225 CLKBUF_X1
X$5050 \$10823 VSS VDD \$11227 CLKBUF_X1
X$5051 \$11227 VSS VDD \$11007 CLKBUF_X1
X$5052 \$6759 \$6756 VSS VDD \$11231 NAND2_X1
X$5053 \$11007 VSS VDD \$11011 CLKBUF_X1
X$5054 \$11229 \$10825 \$11232 VDD VSS \$11328 HA_X1
X$5056 \$11216 VSS VDD \$11207 INV_X1
X$5058 \$8627 \$8269 VSS VDD \$11324 NAND2_X1
X$5059 \$11068 VSS VDD \$11436 INV_X1
X$5061 \$6759 \$8629 VSS VDD \$11547 NAND2_X1
X$5062 \$722 \$6756 VSS VDD \$11325 NAND2_X1
X$5066 \$11231 VSS VDD \$11229 INV_X1
X$5068 \$8568 \$9580 \$11238 VDD VSS \$11327 AND3_X1
X$5069 \$10826 \$11232 \$11238 VDD VSS \$11329 HA_X1
X$5070 \$11242 VSS VDD \$11018 CLKBUF_X1
X$5071 \$10827 VSS VDD \$11242 CLKBUF_X1
X$5077 \$11247 VSS VDD \$10828 CLKBUF_X1
X$5078 \$11246 VSS VDD \$11247 CLKBUF_X1
X$5079 VSS \$10181 \$I100189 \$11074 \$10829 \$10386 VDD DFFR_X1
X$5080 \$11254 VSS VDD \$10769 CLKBUF_X1
X$5081 \$11257 VSS VDD \$11256 CLKBUF_X1
X$5082 \$10831 VSS VDD \$11257 CLKBUF_X1
X$5083 \$11256 VSS VDD \$10183 CLKBUF_X1
X$5084 \$10389 VSS VDD \$11262 CLKBUF_X1
X$5085 \$11262 VSS VDD \$11024 CLKBUF_X1
X$5088 \$11072 VSS VDD \$11246 CLKBUF_X1
X$5089 \$11331 VSS VDD \$10829 CLKBUF_X1
X$5090 \$10830 VSS VDD \$11331 CLKBUF_X1
X$5091 \$10181 VSS VDD \$I68568 INV_X1
X$5094 \$9602 VSS VDD \$9940 CLKBUF_X1
X$5098 \$10765 VSS VDD \$11254 CLKBUF_X1
X$5100 \$11074 VSS VDD \$11265 CLKBUF_X1
X$5102 \$11266 VSS VDD \$11075 CLKBUF_X1
X$5104 \$10833 VSS VDD \$11266 CLKBUF_X1
X$5105 \$11075 VSS VDD \$10778 CLKBUF_X1
X$5106 \$10577 VSS VDD \$11269 CLKBUF_X1
X$5107 \$11269 VSS VDD \$11020 CLKBUF_X1
X$5111 \$11265 VSS VDD \$11267 CLKBUF_X1
X$5114 \$11267 VSS VDD \$11275 CLKBUF_X1
X$5115 VSS \$11272 \$11735 \$11333 \$11270 \$11079 VDD FA_X1
X$5116 \$9773 \$7354 VSS VDD \$11017 NAND2_X1
X$5118 \$8144 \$10835 VSS VDD \$11270 NOR2_X1
X$5119 \$11017 VSS VDD \$11272 INV_X1
X$5120 \$11280 VSS VDD \$8637 CLKBUF_X1
X$5121 \$10571 \$9133 VSS VDD \$11078 NAND2_X1
X$5122 \$11078 VSS VDD \$11079 INV_X1
X$5126 \$11275 VSS VDD \$11292 CLKBUF_X1
X$5128 \$9308 \$10835 VSS VDD \$11283 NOR2_X1
X$5129 VSS \$11081 \$11334 \$11447 \$11283 \$11335 VDD FA_X1
X$5130 \$9773 \$8144 VSS VDD \$10994 NAND2_X1
X$5132 \$10571 \$7354 VSS VDD \$11538 NAND2_X1
X$5133 \$10994 VSS VDD \$11081 INV_X1
X$5138 \$10982 VSS VDD \$10979 CLKBUF_X1
X$5142 \$11292 VSS VDD \$11294 CLKBUF_X1
X$5147 \$11297 VSS VDD \$9292 CLKBUF_X1
X$5149 VSS \$9781 \$I100196 \$11082 \$11294 \$8370 VDD DFFR_X1
X$5151 VSS \$10005 \$I100167 \$11287 \$11299 \$8370 VDD DFFR_X1
X$5152 \$10968 VSS VDD \$11289 CLKBUF_X1
X$5153 \$11289 VSS VDD \$10965 CLKBUF_X1
X$5155 \$10844 VSS VDD \$11085 CLKBUF_X1
X$5156 \$11287 VSS VDD \$10469 CLKBUF_X1
X$5157 \$10700 VSS VDD \$11288 CLKBUF_X1
X$5158 \$11380 VSS VDD \$10699 CLKBUF_X1
X$5159 \$10959 VSS VDD \$11281 CLKBUF_X1
X$5160 \$11281 VSS VDD \$10957 CLKBUF_X1
X$5161 \$10845 VSS VDD \$10847 CLKBUF_X1
X$5165 \$10841 VSS VDD \$11338 CLKBUF_X1
X$5167 \$11082 VSS VDD \$10973 CLKBUF_X1
X$5169 VSS \$11084 \$I99849 \$11341 \$11296 \$8370 VDD DFFR_X1
X$5170 VSS \$11084 \$I100114 \$7212 \$11285 \$8370 VDD DFFR_X1
X$5173 VSS \$11248 \$12112 \$12000 \$10849 \$11088 VDD FA_X1
X$5174 \$9847 \$9152 \$11088 VDD \$11686 VSS OAI21_X1
X$5175 \$9847 \$9153 VSS VDD \$11088 NAND2_X1
X$5176 \$9152 \$8658 VSS VDD \$11248 OR2_X1
X$5177 \$7869 \$9152 VSS VDD \$11252 NOR2_X1
X$5178 \$8658 \$9153 VSS VDD \$11089 NAND2_X1
X$5181 \$11089 VSS VDD \$11342 INV_X1
X$5184 VSS \$11219 \$11515 \$11090 \$11243 \$10854 VDD FA_X1
X$5188 \$9847 \$8168 VSS VDD \$11677 NAND2_X1
X$5191 \$9847 \$7212 VSS VDD \$11344 NAND2_X1
X$5192 \$9847 \$6380 VSS VDD \$11461 NAND2_X1
X$5194 \$11195 VSS VDD \$10908 INV_X1
X$5196 VSS \$10856 \$11096 \$11097 \$10412 \$10892 VDD FA_X1
X$5199 \$7869 \$7212 VSS VDD \$11100 NAND2_X1
X$5200 \$11100 VSS VDD \$11145 INV_X1
X$5203 \$8658 \$8168 VSS VDD \$11345 NAND2_X1
X$5207 \$11094 VSS VDD \$11661 INV_X1
X$5209 \$11096 VSS VDD \$11462 INV_X1
X$5212 \$7869 \$8168 VSS VDD \$11510 NAND2_X1
X$5214 \$8658 \$7212 VSS VDD \$11346 NAND2_X1
X$5216 \$11097 VSS VDD \$11464 INV_X1
X$5219 \$8658 \$6380 VSS VDD \$11099 NAND2_X1
X$5220 \$11099 VSS VDD \$11361 INV_X1
X$5221 VSS \$11145 \$11347 \$10859 \$11143 \$11361 VDD FA_X1
X$5223 \$10886 VSS VDD \$11143 INV_X1
X$5225 \$10859 VSS VDD \$10860 INV_X1
X$5232 \$11142 VSS VDD \$11349 INV_X1
X$5236 \$8690 \$10876 \$11101 VDD VSS \$11102 HA_X1
X$5239 \$10610 VSS VDD \$10873 CLKBUF_X1
X$5240 \$10874 \$10873 VDD VSS \$10862 XNOR2_X1
X$5241 \$10862 VSS VDD \$11106 CLKBUF_X1
X$5242 VSS \$9627 \$I100211 \$10863 \$11106 \$9850 VDD DFFR_X1
X$5249 \$10877 \$11349 \$11348 VDD VSS \$11491 HA_X1
X$5252 \$11101 \$8933 VSS VDD \$11351 NAND2_X1
X$5267 VSS \$476 \$I100277 \$1202 \$1119 \$327 VDD DFFR_X1
X$5272 \$864 \$850 \$947 VDD \$1115 VSS OAI21_X1
X$5275 \$736 VSS VDD \$986 INV_X1
X$5279 \$1202 VSS VDD \$1207 CLKBUF_X1
X$5282 \$1179 \$1294 VDD VSS \$1119 XNOR2_X1
X$5285 \$1294 \$1115 VSS VDD \$1295 NAND2_X1
X$5287 \$1110 VSS VDD \$947 INV_X1
X$5290 \$1105 \$1400 \$734 VDD VSS \$1110 HA_X1
X$5292 VSS \$950 \$1105 \$736 \$1085 \$949 VDD FA_X1
X$5296 \$1094 VSS VDD \$949 INV_X1
X$5298 \$1310 \$959 \$1093 VDD VSS \$950 HA_X1
X$5299 \$1093 VSS VDD \$958 INV_X1
X$5304 VSS \$1312 \$1094 \$1090 \$1307 \$1189 VDD FA_X1
X$5306 \$1088 VSS VDD \$951 INV_X1
X$5307 \$1090 VSS VDD \$959 INV_X1
X$5310 \$1089 VSS VDD \$956 INV_X1
X$5323 \$1180 \$1181 \$1297 VDD VSS \$1089 HA_X1
X$5325 \$1182 \$1508 VSS VDD \$952 NAND2_X1
X$5326 \$1298 VSS VDD \$1182 INV_X1
X$5340 VSS \$3476 \$3470 \$3170 \$3471 \$3172 VDD FA_X1
X$5342 \$3173 VSS VDD \$3172 INV_X1
X$5344 \$3478 VSS VDD \$3476 INV_X1
X$5347 \$3484 VSS VDD \$3216 CLKBUF_X1
X$5348 VSS \$3212 \$3478 \$3175 \$3132 \$3214 VDD FA_X1
X$5349 \$727 \$2759 VSS VDD \$3212 NAND2_X1
X$5350 \$726 \$2759 VSS VDD \$3282 NAND2_X1
X$5351 \$3282 VSS VDD \$3281 INV_X1
X$5354 VSS \$3276 \$3615 \$3173 \$3473 \$3612 VDD FA_X1
X$5355 \$2972 \$1321 VSS VDD \$3276 NAND2_X1
X$5357 \$2057 \$1494 VSS VDD \$3473 NAND2_X1
X$5359 VSS \$3490 \$3637 \$3607 \$3175 \$3604 VDD FA_X1
X$5361 \$3595 VSS VDD \$3490 INV_X1
X$5362 \$3499 \$3281 \$3603 VDD VSS \$3595 HA_X1
X$5365 \$3491 VSS VDD \$3484 CLKBUF_X1
X$5367 VSS \$2215 \$3210 \$1855 \$3589 \$327 VDD DFFR_X1
X$5368 \$2885 VSS VDD \$2959 CLKBUF_X1
X$5370 \$3592 VSS VDD \$3499 INV_X1
X$5373 \$727 \$3032 VSS VDD \$3592 NAND2_X1
X$5377 \$3498 VSS VDD \$2544 CLKBUF_X1
X$5379 VSS \$2215 \$3536 \$2756 \$3997 \$327 VDD DFFR_X1
X$5380 \$3181 VSS VDD \$3464 CLKBUF_X1
X$5381 VSS \$1720 \$3029 \$3180 \$3988 \$327 VDD DFFR_X1
X$5384 VSS \$1720 \$I100360 \$727 \$3986 \$327 VDD DFFR_X1
X$5387 \$3203 \$3183 VDD VSS \$2889 XNOR2_X1
X$5391 \$2756 VSS VDD \$2884 CLKBUF_X1
X$5392 \$3538 VSS VDD \$3482 CLKBUF_X1
X$5393 \$3464 VSS VDD \$3538 CLKBUF_X1
X$5394 \$3179 VSS VDD \$3181 CLKBUF_X1
X$5395 \$3291 VSS VDD \$3579 INV_X1
X$5396 \$3578 \$3579 \$3292 VDD VSS \$4074 HA_X1
X$5397 \$3180 VSS VDD \$3108 CLKBUF_X1
X$5398 \$3844 VSS VDD \$2356 CLKBUF_X1
X$5399 VSS \$1720 \$I99907 \$3440 \$3432 \$327 VDD DFFR_X1
X$5406 \$3430 \$3539 VDD VSS \$3432 XNOR2_X1
X$5409 \$3649 VSS VDD \$3183 INV_X1
X$5410 \$3183 \$3572 \$3540 VDD \$3430 VSS OAI21_X1
X$5413 \$10666 \$10460 VDD VSS \$10796 XNOR2_X1
X$5415 VSS \$9811 \$10166 \$10544 \$10659 \$10461 VDD FA_X1
X$5416 \$10167 \$10546 VDD VSS \$10666 XNOR2_X1
X$5421 \$10376 \$10796 VDD VSS \$10795 XNOR2_X1
X$5425 \$10546 VSS VDD \$10659 INV_X1
X$5428 \$10547 VSS VDD \$10797 INV_X1
X$5429 VSS \$10670 \$10923 \$11159 \$10378 \$9966 VDD FA_X1
X$5431 VSS \$10675 \$10799 \$10167 \$10928 \$10800 VDD FA_X1
X$5433 \$10470 VSS VDD \$10548 INV_X1
X$5436 \$7785 \$9122 VSS VDD \$10552 NAND2_X1
X$5437 \$10552 VSS VDD \$10943 INV_X1
X$5440 \$10549 VSS VDD \$10800 INV_X1
X$5441 \$8535 \$9122 VSS VDD \$10549 NAND2_X1
X$5442 \$10801 VSS VDD \$10675 INV_X1
X$5444 \$8897 \$9122 VSS VDD \$11163 NAND2_X1
X$5445 VSS \$10682 \$11675 \$10805 \$10678 \$10937 VDD FA_X1
X$5448 \$7339 \$8627 VSS VDD \$10551 NAND2_X1
X$5449 \$10551 VSS VDD \$10686 INV_X1
X$5452 VSS \$10686 \$11678 \$10808 \$10943 \$10946 VDD FA_X1
X$5454 \$8897 \$9580 VSS VDD \$10553 NAND2_X1
X$5457 \$7846 \$9122 VSS VDD \$10706 NAND2_X1
X$5460 \$10706 VSS VDD \$10562 INV_X1
X$5462 \$10553 VSS VDD \$10946 INV_X1
X$5464 \$10808 VSS VDD \$10949 INV_X1
X$5465 VSS \$10554 \$10945 \$10810 \$10950 \$10949 VDD FA_X1
X$5469 \$10289 VSS VDD \$10811 INV_X1
X$5473 \$6756 \$9122 VSS VDD \$10558 NAND2_X1
X$5474 \$10558 VSS VDD \$11186 INV_X1
X$5477 \$7785 \$9580 VSS VDD \$11189 NAND2_X1
X$5478 \$10969 VSS VDD \$10813 INV_X1
X$5480 \$8629 \$8627 VSS VDD \$10969 NAND2_X1
X$5483 \$10815 VSS VDD \$10976 INV_X1
X$5484 \$8629 \$9580 VSS VDD \$10815 NAND2_X1
X$5485 VSS \$10383 \$11695 \$10818 \$10562 \$10976 VDD FA_X1
X$5486 \$10384 VSS VDD \$10817 INV_X1
X$5487 \$10563 VSS VDD \$10383 INV_X1
X$5492 \$11540 VSS VDD \$9124 CLKBUF_X1
X$5494 \$9590 VSS VDD \$10491 CLKBUF_X1
X$5496 \$9981 VSS VDD \$10493 CLKBUF_X1
X$5497 \$10176 VSS VDD \$9982 CLKBUF_X1
X$5498 \$10507 VSS VDD \$10564 CLKBUF_X1
X$5499 \$10305 VSS VDD \$10511 CLKBUF_X1
X$5500 \$10564 VSS VDD \$10506 CLKBUF_X1
X$5501 \$10721 VSS VDD \$10313 CLKBUF_X1
X$5502 \$10717 VSS VDD \$10721 CLKBUF_X1
X$5503 \$10565 VSS VDD \$8553 CLKBUF_X1
X$5504 \$10304 VSS VDD \$10566 CLKBUF_X1
X$5507 \$10296 VSS VDD \$10518 CLKBUF_X1
X$5508 \$10734 VSS VDD \$10568 CLKBUF_X1
X$5509 \$10524 VSS VDD \$10734 CLKBUF_X1
X$5510 \$10568 VSS VDD \$9986 CLKBUF_X1
X$5511 \$9987 VSS VDD \$10738 CLKBUF_X1
X$5512 \$10738 VSS VDD \$10523 CLKBUF_X1
X$5513 \$10332 VSS VDD \$10330 CLKBUF_X1
X$5518 \$9592 VSS VDD \$9742 CLKBUF_X1
X$5519 VSS \$9119 \$I99917 \$10823 \$10511 \$10386 VDD DFFR_X1
X$5522 \$10824 VSS VDD \$10825 INV_X1
X$5523 \$722 \$7846 VSS VDD \$10824 NAND2_X1
X$5524 \$11071 VSS VDD \$10569 CLKBUF_X1
X$5526 \$10825 \$9125 \$6759 VDD VSS \$10826 AND3_X1
X$5527 \$11011 VSS VDD \$10827 CLKBUF_X1
X$5530 VSS \$9307 \$I99866 \$11072 \$11018 \$10386 VDD DFFR_X1
X$5531 \$10571 VSS VDD \$10350 CLKBUF_X1
X$5533 \$10751 VSS VDD \$10573 CLKBUF_X1
X$5534 \$10754 VSS VDD \$10346 CLKBUF_X1
X$5535 \$10573 VSS VDD \$9358 CLKBUF_X1
X$5536 \$9778 VSS VDD \$10754 CLKBUF_X1
X$5537 \$10510 VSS VDD \$10765 CLKBUF_X1
X$5538 \$10756 VSS VDD \$10512 CLKBUF_X1
X$5539 \$9943 VSS VDD \$10181 CLKBUF_X3
X$5540 \$10509 VSS VDD \$10756 CLKBUF_X1
X$5541 \$10512 VSS VDD \$10510 CLKBUF_X1
X$5542 VSS \$10181 \$I100292 \$10578 \$10769 \$8370 VDD DFFR_X1
X$5545 \$10828 VSS VDD \$10830 CLKBUF_X1
X$5546 \$10388 VSS VDD \$10751 CLKBUF_X1
X$5547 VSS \$10181 \$I99896 \$10831 \$10513 \$8370 VDD DFFR_X1
X$5548 VSS \$10181 \$I100046 \$10833 \$11024 \$8370 VDD DFFR_X1
X$5549 \$10778 VSS VDD \$10577 CLKBUF_X1
X$5550 \$10775 VSS VDD \$10504 CLKBUF_X1
X$5551 \$10356 VSS VDD \$10361 CLKBUF_X1
X$5553 \$10578 VSS VDD \$10785 CLKBUF_X1
X$5554 \$9994 VSS VDD \$10360 CLKBUF_X1
X$5556 \$9135 VSS VDD \$I93265 CLKBUF_X1
X$5557 \$9943 VSS VDD \$9135 CLKBUF_X3
X$5559 VSS \$9135 \$I100052 \$10836 \$11020 \$8370 VDD DFFR_X1
X$5560 \$10785 VSS VDD \$11004 CLKBUF_X1
X$5562 \$10394 VSS VDD \$10581 CLKBUF_X1
X$5563 \$10581 VSS VDD \$9927 CLKBUF_X1
X$5564 \$10490 VSS VDD \$10763 CLKBUF_X1
X$5567 \$10777 VSS VDD \$10835 INV_X1
X$5568 \$11001 VSS VDD \$9996 CLKBUF_X1
X$5569 \$11004 VSS VDD \$10996 CLKBUF_X1
X$5570 \$10767 VSS VDD \$9837 CLKBUF_X1
X$5571 \$10777 VSS VDD \$10487 CLKBUF_X1
X$5572 \$10487 VSS VDD \$10767 CLKBUF_X1
X$5573 \$10095 VSS VDD \$10755 CLKBUF_X1
X$5574 \$10755 VSS VDD \$10349 CLKBUF_X1
X$5575 \$10763 VSS VDD \$10484 CLKBUF_X1
X$5576 \$9308 VSS VDD \$10982 CLKBUF_X1
X$5578 VSS \$9781 \$I100162 \$9841 \$10735 \$8370 VDD DFFR_X1
X$5579 \$10736 VSS VDD \$10315 CLKBUF_X1
X$5581 \$10730 VSS VDD \$10729 CLKBUF_X1
X$5582 \$10478 VSS VDD \$10322 CLKBUF_X1
X$5583 VSS \$9781 \$I100172 \$10715 \$10724 \$8370 VDD DFFR_X1
X$5585 \$10836 VSS VDD \$10762 CLKBUF_X1
X$5586 \$9836 VSS VDD \$11001 CLKBUF_X1
X$5588 \$10996 VSS VDD \$10582 CLKBUF_X1
X$5591 \$10762 VSS VDD \$10989 CLKBUF_X1
X$5593 \$10190 VSS VDD \$10090 CLKBUF_X1
X$5596 \$10188 VSS VDD \$10191 CLKBUF_X1
X$5597 \$10484 VSS VDD \$10736 CLKBUF_X1
X$5599 \$10989 VSS VDD \$10730 CLKBUF_X1
X$5600 \$10582 VSS VDD \$10724 CLKBUF_X1
X$5604 \$10324 VSS VDD \$10192 CLKBUF_X1
X$5609 \$10729 VSS VDD \$10954 CLKBUF_X1
X$5610 \$10715 VSS VDD \$10471 CLKBUF_X1
X$5611 \$11338 VSS VDD \$10714 CLKBUF_X1
X$5612 \$10973 VSS VDD \$10841 CLKBUF_X1
X$5614 VSS \$10005 \$I99933 \$10700 \$10965 \$8370 VDD DFFR_X1
X$5616 \$10714 VSS VDD \$10968 CLKBUF_X1
X$5617 VSS \$10005 \$I100373 \$6380 \$10695 \$8370 VDD DFFR_X1
X$5618 VSS \$10005 \$I100160 \$10960 \$10075 \$8370 VDD DFFR_X1
X$5619 \$8168 VSS VDD \$10006 CLKBUF_X1
X$5621 \$10466 VSS VDD \$10465 CLKBUF_X1
X$5624 VSS \$10005 \$I100009 \$8168 \$10957 \$8370 VDD DFFR_X1
X$5625 \$10960 VSS VDD \$10846 CLKBUF_X1
X$5626 \$10951 VSS VDD \$10845 CLKBUF_X1
X$5627 \$10846 VSS VDD \$10951 CLKBUF_X1
X$5628 \$10847 VSS VDD \$10948 CLKBUF_X1
X$5629 \$10948 VSS VDD \$10695 CLKBUF_X1
X$5630 \$7212 VSS VDD \$10593 CLKBUF_X1
X$5631 \$10400 VSS VDD \$10401 CLKBUF_X1
X$5633 \$10459 VSS VDD \$10692 CLKBUF_X1
X$5634 \$10593 VSS VDD \$8926 CLKBUF_X1
X$5635 \$10692 VSS VDD \$10404 CLKBUF_X1
X$5639 \$9847 \$8395 VSS VDD \$10849 NAND2_X1
X$5643 \$9153 \$7869 VSS VDD \$10597 NAND2_X1
X$5645 \$10405 VSS VDD \$10407 CLKBUF_X1
X$5647 \$6987 \$9152 VSS VDD \$10598 NOR2_X1
X$5648 \$7869 \$8395 VSS VDD \$11195 NAND2_X1
X$5649 \$9153 \$7877 VSS VDD \$10601 NAND2_X1
X$5650 \$10601 VSS VDD \$10676 INV_X1
X$5654 \$7877 \$9152 VSS VDD \$11243 NOR2_X1
X$5655 \$10597 VSS VDD \$11219 INV_X1
X$5656 \$10853 VSS VDD \$10854 INV_X1
X$5658 \$8658 \$8395 VSS VDD \$10853 NAND2_X1
X$5662 VSS \$10676 \$11343 \$11094 \$10598 \$10908 VDD FA_X1
X$5667 \$8395 \$7877 VSS VDD \$10602 NAND2_X1
X$5668 \$10602 VSS VDD \$10892 INV_X1
X$5669 \$9153 \$6987 VSS VDD \$10603 NAND2_X1
X$5671 \$8395 \$6987 VSS VDD \$10604 NAND2_X1
X$5672 \$10604 VSS VDD \$10449 INV_X1
X$5675 \$10603 VSS VDD \$10856 INV_X1
X$5678 \$10898 VSS VDD \$11364 INV_X1
X$5680 \$10250 VSS VDD \$10655 INV_X1
X$5681 \$10446 VSS VDD \$10652 INV_X1
X$5682 VSS \$10655 \$10606 \$10881 \$10649 \$10044 VDD FA_X1
X$5686 VSS \$10014 \$10607 \$11142 \$10641 \$10442 VDD FA_X1
X$5691 \$7877 \$8168 VSS VDD \$10886 NAND2_X1
X$5692 VSS \$10648 \$10858 \$10645 \$10652 \$10860 VDD FA_X1
X$5693 VSS \$10642 \$11465 \$10641 \$10645 \$10881 VDD FA_X1
X$5695 \$10415 VSS VDD \$10877 INV_X1
X$5699 \$10416 VSS VDD \$10876 INV_X1
X$5701 \$10608 VSS VDD \$10228 CLKBUF_X1
X$5703 \$10436 VSS VDD \$10608 CLKBUF_X1
X$5705 \$10417 VSS VDD \$10436 CLKBUF_X1
X$5706 \$10421 \$10609 VDD VSS \$10419 AND2_X1
X$5707 \$10202 VSS VDD \$10609 CLKBUF_X1
X$5709 \$10016 VSS VDD \$10875 CLKBUF_X1
X$5710 \$9627 VSS VDD \$I101761 INV_X4
X$5711 \$10610 \$10627 \$10425 VSS VDD \$10611 NAND3_X1
X$5712 \$10433 \$10610 VSS VDD \$10621 NAND2_X1
X$5715 \$10017 VSS VDD \$10874 CLKBUF_X1
X$5716 \$10875 \$10867 \$10610 VDD VSS \$10871 HA_X1
X$5717 \$10621 \$10861 \$10611 VSS VDD \$11353 NAND3_X1
X$5721 \$10871 VSS VDD \$10861 INV_X1
X$5722 \$10421 \$10863 VDD VSS \$10867 AND2_X1
X$5723 \$10213 VSS VDD \$10426 INV_X1
X$5724 \$10619 \$10421 VSS VDD \$10213 NAND2_X1
X$5727 \$10422 VSS VDD \$10619 CLKBUF_X1
X$5738 \$11611 \$10202 \$10422 \$10863 VDD \$10615 VSS NOR4_X2
X$5746 \$17560 VSS VDD \$17671 INV_X1
X$5747 \$17668 VSS VDD \$17669 INV_X1
X$5748 \$17399 \$17669 \$17671 VDD \$17608 VSS OAI21_X1
X$5751 \$17348 \$17485 VSS VDD \$17601 NOR2_X1
X$5753 \$17602 \$17567 VDD VSS \$17674 XNOR2_X1
X$5756 \$17408 \$17570 VSS VDD \$17587 NAND2_X1
X$5757 \$17731 VSS VDD \$17272 INV_X1
X$5760 \$17672 VSS VDD \$18022 INV_X1
X$5761 \$17669 VSS VDD \$17885 CLKBUF_X1
X$5762 \$17672 \$17885 VDD VSS \$18014 XNOR2_X1
X$5764 VSS \$16572 \$I99874 \$17840 \$17883 \$15181 VDD DFFR_X1
X$5771 \$17407 \$17569 VDD VSS \$18009 XNOR2_X1
X$5774 \$17408 VSS VDD \$17569 CLKBUF_X1
X$5775 \$17731 \$17570 \$17677 VSS \$17407 VDD AOI21_X1
X$5777 \$17731 \$17570 \$17463 VSS \$17584 VDD AOI21_X1
X$5780 \$17275 VSS VDD \$I93188 CLKBUF_X1
X$5783 \$17097 \$17843 \$17570 VDD VSS \$17731 HA_X1
X$5788 \$17411 \$17679 VDD VSS \$17870 AND2_X1
X$5789 \$15560 VSS VDD \$17275 CLKBUF_X3
X$5790 \$17410 \$17870 \$17724 VDD VSS \$17715 HA_X1
X$5791 \$17715 VSS VDD \$17844 INV_X1
X$5792 \$17724 \$17694 VSS VDD \$17859 NAND2_X1
X$5794 \$17572 VSS VDD \$17714 INV_X1
X$5795 \$17714 VSS VDD \$17439 CLKBUF_X1
X$5798 \$15027 VSS VDD \$14912 INV_X1
X$5799 VSS \$13947 \$15224 \$15027 \$14005 \$14506 VDD FA_X1
X$5800 VSS \$14508 \$15226 \$14842 \$13544 \$14912 VDD FA_X1
X$5801 \$13630 \$11303 VSS VDD \$14962 NAND2_X1
X$5802 \$14962 VSS VDD \$15040 INV_X1
X$5803 \$11561 \$12618 VDD VSS \$14963 AND2_X1
X$5805 \$15224 VSS VDD \$15225 INV_X1
X$5810 VSS \$15040 \$15161 \$15042 \$14722 \$14963 VDD FA_X1
X$5811 \$15042 VSS VDD \$14733 INV_X1
X$5816 \$14964 VSS VDD \$14919 INV_X1
X$5817 \$12618 \$11303 VSS VDD \$14964 NAND2_X1
X$5819 \$14965 VSS VDD \$15045 INV_X1
X$5821 VSS \$14510 \$14968 \$15435 \$13956 \$14922 VDD FA_X1
X$5822 VSS \$15054 \$14965 \$14922 \$14736 \$14919 VDD FA_X1
X$5825 \$12827 \$11303 VSS VDD \$15245 NAND2_X1
X$5831 \$12827 \$11561 VSS VDD \$15430 NAND2_X1
X$5835 \$11561 VSS VDD \$15247 INV_X1
X$5838 \$15245 VSS VDD \$15246 INV_X1
X$5839 \$12691 \$15247 VSS VDD \$15249 NOR2_X1
X$5840 \$15249 \$15246 \$14754 VDD VSS \$15061 HA_X1
X$5841 \$14755 VSS VDD \$15600 INV_X1
X$5842 \$14849 VSS VDD \$15442 INV_X1
X$5844 VSS \$14970 \$15380 \$15255 \$14850 \$14324 VDD FA_X1
X$5851 \$13966 \$15255 \$15163 VDD VSS \$15258 HA_X1
X$5852 \$15258 VSS VDD \$15257 INV_X1
X$5855 \$14393 \$14852 \$15078 VDD VSS \$14971 HA_X1
X$5856 \$14690 \$13818 \$15167 VSS VDD NOR2_X4
X$5857 \$14685 VSS VDD \$14853 CLKBUF_X1
X$5858 \$15080 VSS VDD \$14938 CLKBUF_X1
X$5859 \$14685 \$15078 \$14687 VSS VDD \$14977 NAND3_X1
X$5860 \$14857 VSS VDD \$15088 INV_X1
X$5861 \$15092 \$14938 VSS VDD \$14978 XOR2_X1
X$5863 \$14979 \$14858 VDD VSS \$14980 XNOR2_X1
X$5865 \$14980 VSS VDD \$15097 CLKBUF_X1
X$5866 VSS \$14238 \$14861 \$14859 \$15097 \$10386 VDD DFFR_X1
X$5867 \$14691 \$14690 \$14982 \$14859 VSS VDD \$14949 NAND4_X1
X$5868 \$14984 \$14955 \$14860 VSS \$14946 VDD AOI21_X1
X$5869 \$14861 \$14949 \$14863 VDD VSS \$14983 HA_X1
X$5870 \$14862 \$15117 VSS VDD \$14985 NAND2_X1
X$5872 \$14863 VSS VDD \$14955 INV_X1
X$5876 \$15078 VSS VDD \$14974 CLKBUF_X1
X$5877 \$14683 VSS VDD \$14393 CLKBUF_X1
X$5878 \$14971 VSS VDD \$14855 INV_X1
X$5879 \$14971 \$14685 VSS VDD \$14975 NAND2_X1
X$5880 \$14974 VSS VDD \$14684 INV_X1
X$5881 \$14975 \$15088 \$14977 VSS VDD \$14979 NAND3_X1
X$5882 \$14853 VSS VDD \$15267 INV_X1
X$5883 \$14854 \$15267 VDD VSS \$15171 XNOR2_X1
X$5884 \$14978 VSS VDD \$14688 CLKBUF_X1
X$5888 \$15272 VSS VDD \$14860 INV_X1
X$5889 \$14982 \$14859 VSS VDD \$14805 NOR2_X1
X$5890 \$14692 \$14984 \$14852 VSS VDD NOR2_X4
X$5891 \$14983 \$14984 VSS VDD \$15092 NOR2_X1
X$5893 \$14985 VSS VDD \$14984 INV_X4
X$5895 \$14863 \$14984 \$14108 VSS VDD NOR2_X4
X$5910 \$12743 VSS VDD \$14244 CLKBUF_X3
X$5912 VSS \$14990 \$I100424 \$14359 \$15122 \$10386 VDD DFFR_X1
X$5917 \$15178 VSS VDD \$15179 CLKBUF_X1
X$5918 \$14991 VSS VDD \$15122 CLKBUF_X1
X$5920 VSS \$14244 \$I100465 \$14400 \$15128 \$10386 VDD DFFR_X1
X$5922 VSS \$14252 \$I100417 \$14993 \$14864 \$15181 VDD DFFR_X1
X$5924 \$14999 \$14953 \$14995 VDD VSS \$14867 HA_X1
X$5925 \$14867 \$14995 \$14868 VSS \$15153 VDD AOI21_X1
X$5926 \$14996 VSS VDD \$14868 INV_X1
X$5927 \$15000 VSS VDD \$14869 INV_X1
X$5928 \$14869 \$15153 \$14870 VDD \$15155 VSS OAI21_X1
X$5929 \$14871 VSS VDD \$14870 INV_X1
X$5932 \$15155 \$15002 VDD VSS \$14873 XNOR2_X1
X$5936 VSS \$15007 \$I100273 \$15401 \$14496 \$15181 VDD DFFR_X1
X$5939 \$14884 VSS VDD \$14118 CLKBUF_X1
X$5941 \$15460 VSS VDD \$15008 CLKBUF_X1
X$5943 \$15151 VSS VDD \$14051 CLKBUF_X1
X$5946 \$14873 \$15010 \$14876 VSS VDD \$14874 NAND3_X2
X$5947 \$14873 VSS VDD \$15145 INV_X1
X$5949 \$15145 \$14875 VSS \$15365 VDD NAND2_X4
X$5950 \$15010 \$14876 VSS VDD \$14875 NAND2_X2
X$5951 \$15131 \$14878 VSS \$15010 VDD NAND2_X4
X$5952 \$14879 VSS VDD \$15131 INV_X2
X$5954 \$14697 \$14820 \$14879 VSS VDD \$14876 NAND3_X2
X$5955 \$14939 VSS VDD \$14880 INV_X1
X$5956 \$15013 \$14881 VSS VDD \$14879 XNOR2_X2
X$5958 \$15336 \$14883 \$15014 VDD \$14814 VSS OAI21_X1
X$5960 \$15115 VSS VDD \$15014 INV_X1
X$5964 \$15393 VSS VDD \$15128 CLKBUF_X1
X$5966 \$14992 VSS VDD \$15299 INV_X1
X$5968 \$15183 VSS VDD \$15184 CLKBUF_X1
X$5969 \$15185 VSS VDD \$14864 CLKBUF_X1
X$5973 \$14959 VSS VDD \$15133 INV_X1
X$5974 \$14993 VSS VDD \$14998 CLKBUF_X1
X$5975 \$14995 VSS VDD \$14959 CLKBUF_X1
X$5976 \$15133 \$15396 \$14866 VDD \$14531 VSS OAI21_X1
X$5977 \$14998 VSS VDD \$14999 CLKBUF_X1
X$5979 \$15317 VSS VDD \$15000 CLKBUF_X1
X$5980 \$15001 \$15320 \$15317 VDD VSS \$14871 HA_X1
X$5981 \$15004 VSS VDD \$15320 INV_X1
X$5984 \$15003 VSS VDD \$15002 CLKBUF_X1
X$5987 VSS \$15509 \$I99837 \$15514 \$15005 \$15181 VDD DFFR_X1
X$5988 VSS \$15189 \$I99977 \$15160 \$14537 \$15181 VDD DFFR_X1
X$5989 \$15190 VSS VDD \$14834 CLKBUF_X1
X$5993 \$15339 VSS VDD \$15006 CLKBUF_X1
X$5995 VSS \$15007 \$I100000 \$15194 \$14257 \$15181 VDD DFFR_X1
X$5997 VSS \$15406 \$I100144 \$15364 \$15357 \$15181 VDD DFFR_X1
X$6002 \$15364 VSS VDD \$15367 CLKBUF_X1
X$6003 \$15367 VSS VDD \$15370 CLKBUF_X1
X$6005 VSS \$15007 \$I99968 \$15368 \$15009 \$15181 VDD DFFR_X1
X$6008 \$15369 \$15365 VSS \$15143 VDD NAND2_X4
X$6009 \$15198 VSS VDD \$15199 CLKBUF_X1
X$6011 VSS \$11084 \$13844 \$14939 \$15200 \$9850 VDD DFFR_X1
X$6012 \$13515 \$13678 VSS VDD \$15344 XOR2_X1
X$6013 \$15344 \$13989 VSS \$15013 VDD NAND2_X4
X$6014 \$14883 \$15336 VDD VSS \$15004 XNOR2_X1
X$6017 \$15334 VSS VDD \$15336 INV_X1
X$6018 \$15203 \$15331 \$15334 VDD VSS \$15115 HA_X1
X$6021 \$15327 VSS VDD \$15204 INV_X1
X$6022 VSS \$14323 \$15327 \$15312 \$14543 \$15318 VDD FA_X1
X$6024 VSS \$15098 \$15318 \$15096 \$15099 \$14603 VDD FA_X1
X$6027 \$13515 \$13398 VSS VDD \$15281 NAND2_X1
X$6029 \$15079 VSS VDD \$15019 INV_X1
X$6031 \$13678 \$13680 VSS VDD \$15079 NAND2_X1
X$6035 \$15312 VSS VDD \$15309 INV_X1
X$6037 \$15310 VSS VDD \$15099 INV_X1
X$6038 \$14273 \$13679 VSS VDD \$15310 NAND2_X1
X$6042 \$15096 VSS VDD \$15295 INV_X1
X$6043 VSS \$15090 \$15294 \$15018 \$14931 \$15295 VDD FA_X1
X$6044 \$15085 VSS VDD \$15090 INV_X1
X$6046 VSS \$15077 \$15085 \$15209 \$15289 \$15019 VDD FA_X1
X$6047 \$15281 VSS VDD \$15077 INV_X1
X$6049 \$14574 VSS VDD \$14928 CLKBUF_X1
X$6050 \$14770 VSS VDD \$14547 INV_X1
X$6051 VSS \$13995 \$15065 \$15066 \$13270 \$9850 VDD DFFR_X1
X$6052 \$15066 VSS VDD \$15068 CLKBUF_X1
X$6054 \$14143 VSS VDD \$12651 INV_X2
X$6057 \$15063 VSS VDD \$15021 CLKBUF_X1
X$6060 \$14892 VSS VDD \$14553 INV_X1
X$6062 \$15068 VSS VDD \$14546 CLKBUF_X1
X$6067 \$15065 VSS VDD \$15063 CLKBUF_X1
X$6070 \$15021 VSS VDD \$15051 CLKBUF_X1
X$6071 \$14546 \$14901 \$14894 VDD VSS \$15234 HA_X1
X$6072 \$14895 \$14894 VSS VDD \$15056 NAND2_X1
X$6073 \$14900 \$15051 VSS VDD \$15050 XOR2_X1
X$6074 \$15050 VSS VDD \$15047 CLKBUF_X1
X$6077 \$14726 \$15238 VDD VSS \$15237 XNOR2_X1
X$6078 \$14894 VSS VDD \$15238 INV_X1
X$6079 \$15056 \$15235 \$14897 VSS VDD \$15052 NAND3_X1
X$6080 \$15234 VSS VDD \$15235 INV_X1
X$6081 \$15052 \$15047 VDD VSS \$15220 XNOR2_X1
X$6085 VSS \$14280 \$15221 \$14282 \$15023 \$9850 VDD DFFR_X1
X$6086 \$14902 VSS VDD \$14899 INV_X1
X$6088 \$14902 \$14288 VSS VDD \$14909 NOR2_X1
X$6089 \$14906 \$14904 \$14714 VSS \$14900 VDD AOI21_X1
X$6090 \$14909 \$14904 \$14714 VSS \$14901 VDD AOI21_X1
X$6092 \$15222 \$14285 \$14902 VDD VSS \$14906 HA_X1
X$6101 \$15222 \$15024 VDD \$14904 VSS XOR2_X2
X$6109 \$16108 VSS VDD \$16646 INV_X1
X$6111 \$16643 VSS VDD \$16931 INV_X1
X$6112 \$16725 VSS VDD \$16928 CLKBUF_X1
X$6113 \$16928 VSS VDD \$16937 CLKBUF_X1
X$6114 \$16931 \$16644 \$16458 VDD \$16737 VSS OAI21_X1
X$6116 \$16459 \$16455 \$16649 VSS \$16644 VDD AOI21_X1
X$6118 \$16649 \$16313 VDD VSS \$16943 XNOR2_X1
X$6122 \$16947 VSS VDD \$16860 CLKBUF_X1
X$6125 VSS \$16461 \$I100455 \$17312 \$16952 \$12319 VDD DFFR_X1
X$6126 \$16762 VSS VDD \$16767 CLKBUF_X1
X$6128 VSS \$16461 \$I100365 \$17163 \$16653 \$12319 VDD DFFR_X1
X$6129 VSS \$16319 \$I100483 \$17054 \$16656 \$12319 VDD DFFR_X1
X$6130 \$16780 VSS VDD \$16784 CLKBUF_X1
X$6131 VSS \$16319 \$I100412 \$15385 \$16871 \$12319 VDD DFFR_X1
X$6132 \$16983 VSS VDD \$16468 CLKBUF_X1
X$6133 \$16793 VSS VDD \$16983 CLKBUF_X1
X$6137 xin[4] VSS VDD \$16921 BUF_X1
X$6139 VSS \$16449 \$I100469 \$16922 \$16921 \$15672 VDD DFFR_X1
X$6140 VSS \$16449 \$16641 \$13958 \$16639 \$15672 VDD DFFR_X1
X$6152 \$16449 VSS VDD \$I101700 INV_X2
X$6153 \$16922 VSS VDD \$17242 CLKBUF_X1
X$6154 \$17110 VSS VDD \$16449 CLKBUF_X3
X$6156 \$16926 VSS VDD \$17045 CLKBUF_X1
X$6157 \$17118 VSS VDD \$16639 CLKBUF_X1
X$6158 \$17045 VSS VDD \$17118 CLKBUF_X1
X$6159 \$17115 VSS VDD \$16926 CLKBUF_X1
X$6162 \$13958 VSS VDD \$17121 CLKBUF_X1
X$6164 \$17121 VSS VDD \$17127 CLKBUF_X1
X$6165 \$16644 \$16643 VDD VSS \$18388 XNOR2_X1
X$6166 \$16737 \$16646 VDD VSS \$17046 XNOR2_X1
X$6168 \$17127 VSS VDD \$17047 CLKBUF_X1
X$6170 \$16937 VSS VDD \$17134 CLKBUF_X1
X$6171 \$17047 VSS VDD \$16953 CLKBUF_X1
X$6173 VSS \$17372 \$I99878 \$17142 \$17134 \$12319 VDD DFFR_X1
X$6174 \$16953 VSS VDD \$16952 CLKBUF_X1
X$6175 \$17048 VSS VDD \$17301 CLKBUF_X1
X$6176 \$16862 VSS VDD \$17048 CLKBUF_X1
X$6178 \$17147 VSS VDD \$17050 CLKBUF_X1
X$6179 VSS \$16461 \$I100145 \$16864 \$17051 \$12319 VDD DFFR_X1
X$6180 VSS \$16461 \$I99972 \$16866 \$17156 \$12319 VDD DFFR_X1
X$6182 VSS \$16319 \$I100091 \$17055 \$16868 \$15672 VDD DFFR_X1
X$6183 \$17171 VSS VDD \$17056 CLKBUF_X1
X$6184 \$16870 VSS VDD \$17057 CLKBUF_X1
X$6185 \$17173 VSS VDD \$16871 CLKBUF_X1
X$6186 \$17057 VSS VDD \$17173 CLKBUF_X1
X$6187 \$17174 VSS VDD \$17176 CLKBUF_X1
X$6188 \$17176 VSS VDD \$17177 CLKBUF_X1
X$6189 \$17177 VSS VDD \$16873 CLKBUF_X1
X$6192 \$16985 VSS VDD \$17059 INV_X1
X$6193 \$15458 \$14199 VSS VDD \$16985 NAND2_X1
X$6195 \$15385 VSS VDD \$17182 CLKBUF_X1
X$6196 \$16875 VSS VDD \$16802 INV_X1
X$6197 \$15458 \$13414 VSS VDD \$16875 NAND2_X1
X$6198 \$15385 \$14199 VSS VDD \$16876 NAND2_X1
X$6200 \$16876 VSS VDD \$16996 INV_X1
X$6201 \$16996 \$16802 \$16803 VDD VSS \$17001 HA_X1
X$6203 \$17060 \$17059 \$16998 VDD VSS \$17484 HA_X1
X$6205 \$17182 VSS VDD \$17346 CLKBUF_X1
X$6206 VSS \$16998 \$16877 \$17194 \$17000 \$17001 VDD FA_X1
X$6208 \$16661 VSS VDD \$17008 CLKBUF_X1
X$6210 \$15388 \$13098 VSS VDD \$16878 NAND2_X1
X$6212 \$16878 VSS VDD \$17064 INV_X1
X$6213 \$16323 \$13041 VSS VDD \$16880 NAND2_X1
X$6214 \$16880 VSS VDD \$16881 INV_X1
X$6217 \$17008 VSS VDD \$17009 CLKBUF_X1
X$6220 VSS \$16881 \$17000 \$17195 \$17187 \$17064 VDD FA_X1
X$6221 \$17186 VSS VDD \$17199 CLKBUF_X1
X$6223 \$17065 \$17195 \$16882 VDD VSS \$17353 HA_X1
X$6224 VSS \$16664 \$17017 \$16824 \$17197 \$16605 VDD FA_X1
X$6231 \$17009 VSS VDD \$17021 CLKBUF_X1
X$6236 \$17199 VSS VDD \$17013 CLKBUF_X1
X$6238 \$17015 \$16828 VSS VDD \$17387 NAND2_X1
X$6239 \$17016 VSS VDD \$17015 INV_X1
X$6240 \$17021 \$16832 \$16883 VDD VSS \$16885 HA_X1
X$6243 \$16883 VSS VDD \$17201 CLKBUF_X1
X$6244 \$17201 VSS VDD \$16884 CLKBUF_X1
X$6245 VSS \$16886 \$I100002 \$17388 \$16884 \$15541 VDD DFFR_X1
X$6246 VSS \$16886 \$I100390 \$17070 \$17013 \$15541 VDD DFFR_X1
X$6248 \$17071 VSS VDD \$17072 CLKBUF_X1
X$6249 \$17032 VSS VDD \$16666 CLKBUF_X1
X$6250 VSS \$17041 \$I100349 \$16888 \$17073 \$15181 VDD DFFR_X1
X$6253 VSS \$17041 \$I100068 \$17074 \$17069 \$15541 VDD DFFR_X1
X$6254 \$17075 VSS VDD \$17209 CLKBUF_X1
X$6255 \$17076 \$17221 \$16474 VDD VSS \$17077 HA_X1
X$6258 \$16888 VSS VDD \$17214 CLKBUF_X1
X$6259 \$17214 VSS VDD \$17213 CLKBUF_X1
X$6260 \$17043 VSS VDD \$16848 CLKBUF_X1
X$6261 VSS \$17041 \$I100320 \$17043 \$16668 \$15181 VDD DFFR_X1
X$6263 \$17213 VSS VDD \$16889 CLKBUF_X1
X$6264 \$17211 VSS VDD \$16668 CLKBUF_X1
X$6265 \$16889 VSS VDD \$17078 CLKBUF_X1
X$6267 \$17079 VSS VDD \$17217 CLKBUF_X1
X$6268 VSS \$16890 \$I100095 \$17083 \$17217 \$15181 VDD DFFR_X1
X$6269 VSS \$16890 \$I100201 \$15924 \$16671 \$15181 VDD DFFR_X1
X$6270 VSS \$16890 \$I100197 \$16850 \$17082 \$15181 VDD DFFR_X1
X$6273 \$17084 VSS VDD \$17231 CLKBUF_X1
X$6274 \$17236 VSS VDD \$17257 CLKBUF_X1
X$6275 \$17233 VSS VDD \$16671 CLKBUF_X1
X$6276 VSS \$16890 \$I99867 \$16672 \$17232 \$16907 VDD DFFR_X1
X$6277 \$17037 \$17234 \$17034 VDD VSS \$17237 HA_X1
X$6278 \$16672 VSS VDD \$17031 CLKBUF_X1
X$6281 \$17034 \$17028 \$16673 VSS VDD \$16893 NAND3_X1
X$6283 \$17237 VSS VDD \$17235 INV_X1
X$6284 \$17235 \$16893 VSS VDD \$17239 NAND2_X1
X$6285 VSS \$17024 \$17037 \$17028 \$17227 \$17018 VDD FA_X1
X$6287 \$17031 VSS VDD \$17029 CLKBUF_X1
X$6288 \$17029 VSS VDD \$17022 CLKBUF_X1
X$6290 \$17224 \$17226 \$16894 VDD VSS \$17024 HA_X1
X$6291 \$17022 VSS VDD \$16835 CLKBUF_X1
X$6293 \$17007 \$16485 \$16849 VDD VSS \$17020 HA_X1
X$6294 \$15506 \$16677 VSS VDD \$16895 NAND2_X1
X$6295 \$16895 VSS VDD \$17216 INV_X1
X$6296 \$16679 VSS VDD \$17218 INV_X1
X$6297 \$17010 \$16486 VSS VDD \$16679 NAND2_X1
X$6299 \$16680 VSS VDD \$17007 INV_X1
X$6303 \$17020 \$17219 \$17226 VDD VSS \$17018 HA_X1
X$6304 \$17218 \$17216 \$17224 VDD VSS \$17086 HA_X1
X$6306 \$16672 \$17398 VSS VDD \$16680 NAND2_X1
X$6308 \$17260 VSS VDD \$16596 CLKBUF_X1
X$6309 \$15560 VSS VDD \$16489 CLKBUF_X3
X$6310 \$16489 VSS VDD \$I68532 INV_X1
X$6313 \$17003 VSS VDD \$16898 CLKBUF_X1
X$6314 \$16833 VSS VDD \$16984 CLKBUF_X1
X$6315 \$16988 VSS VDD \$16899 CLKBUF_X1
X$6316 \$16993 VSS VDD \$16833 CLKBUF_X1
X$6317 \$16682 VSS VDD \$16681 CLKBUF_X1
X$6318 \$16984 VSS VDD \$16988 CLKBUF_X1
X$6322 \$16899 VSS VDD \$16682 CLKBUF_X1
X$6325 \$16982 VSS VDD \$16684 CLKBUF_X1
X$6326 \$16683 VSS VDD \$16685 CLKBUF_X1
X$6327 \$16685 VSS VDD \$16900 CLKBUF_X1
X$6328 \$16686 VSS VDD \$16982 CLKBUF_X1
X$6329 \$16900 VSS VDD \$16816 CLKBUF_X1
X$6331 \$16977 VSS VDD \$16804 CLKBUF_X1
X$6332 \$16796 VSS VDD \$16795 CLKBUF_X1
X$6334 VSS \$16572 \$I100173 \$16903 \$17761 \$15181 VDD DFFR_X1
X$6335 \$16904 VSS VDD \$16974 CLKBUF_X1
X$6336 \$16974 VSS VDD \$16688 CLKBUF_X1
X$6337 \$16689 \$16486 \$16905 VDD VSS \$17183 HA_X1
X$6340 VSS \$16572 \$I99820 \$17563 \$17202 \$15181 VDD DFFR_X1
X$6342 \$16491 \$16677 \$17089 VDD VSS \$17267 HA_X1
X$6345 \$16903 VSS VDD \$17189 CLKBUF_X1
X$6346 \$17189 VSS VDD \$17192 CLKBUF_X1
X$6347 \$17192 VSS VDD \$16904 CLKBUF_X1
X$6352 \$17183 \$17089 VSS VDD \$17090 NAND2_X1
X$6353 \$16905 VSS VDD \$16906 CLKBUF_X1
X$6354 \$16906 VSS VDD \$17092 INV_X1
X$6355 \$17183 VSS VDD \$17093 INV_X1
X$6358 \$17095 \$17092 VDD VSS \$17331 XNOR2_X1
X$6360 \$16690 VSS VDD \$17097 CLKBUF_X1
X$6362 \$16966 VSS VDD \$17101 CLKBUF_X1
X$6364 \$16968 \$17278 \$16970 VDD VSS \$16782 HA_X1
X$6365 \$16965 VSS VDD \$16909 CLKBUF_X1
X$6371 VSS \$15933 \$I99840 \$17099 \$17166 \$16907 VDD DFFR_X1
X$6372 VSS \$17275 \$I99880 \$17315 \$17100 \$16907 VDD DFFR_X1
X$6373 \$16970 VSS VDD \$16966 CLKBUF_X1
X$6374 \$16909 VSS VDD \$16968 CLKBUF_X1
X$6377 \$16775 \$16962 VSS VDD \$16551 NAND2_X1
X$6379 \$16910 \$16692 VDD VSS \$16548 XNOR2_X1
X$6380 \$16692 \$16910 VSS VDD \$16962 NAND2_X1
X$6381 \$16958 VSS VDD \$17153 INV_X1
X$6382 \$16911 VSS VDD \$16775 INV_X1
X$6386 VSS \$16957 \$16912 \$16954 \$16695 \$16743 VDD FA_X1
X$6387 VSS \$16696 \$16695 \$17135 \$16355 \$16697 VDD FA_X1
X$6390 VSS \$16946 \$16913 \$16944 \$16945 \$16734 VDD FA_X1
X$6392 \$16741 \$16729 \$16927 VDD VSS \$16914 HA_X1
X$6393 VSS \$16730 \$16938 \$16729 \$15960 \$16507 VDD FA_X1
X$6398 \$17148 \$17153 \$16692 VDD VSS \$16911 HA_X1
X$6401 \$17145 VSS VDD \$17148 INV_X1
X$6406 \$16912 VSS VDD \$17102 INV_X1
X$6409 VSS \$16949 \$17283 \$17293 \$16501 \$16954 VDD FA_X1
X$6410 \$17135 \$16521 \$16948 VDD VSS \$16949 HA_X1
X$6413 \$16913 VSS VDD \$17105 INV_X1
X$6417 VSS \$16505 \$17284 \$16941 \$16948 \$16944 VDD FA_X1
X$6418 VSS \$16914 \$17106 \$17116 \$16941 \$16938 VDD FA_X1
X$6422 \$16700 \$16699 VDD VSS \$16516 XNOR2_X1
X$6425 \$16699 \$16700 VSS VDD \$16915 NAND2_X1
X$6426 \$16927 VSS VDD \$16924 INV_X1
X$6427 VSS \$16706 \$16917 \$16925 \$16924 \$16713 VDD FA_X1
X$6428 \$16925 VSS VDD \$16701 INV_X1
X$6431 \$16918 \$16509 VSS VDD \$16700 NAND2_X1
X$6432 \$16702 VSS VDD \$16918 INV_X1
X$6439 \$17107 \$17116 \$16699 VDD VSS \$16916 HA_X1
X$6441 \$16917 VSS VDD \$17107 INV_X1
X$6453 \$12094 VSS VDD \$12093 INV_X1
X$6457 \$12068 \$12093 \$12069 VDD VSS \$12089 HA_X1
X$6460 VSS \$12188 \$12317 \$12094 \$12096 \$12067 VDD FA_X1
X$6461 \$12317 VSS VDD \$12438 INV_X1
X$6464 \$12069 VSS VDD \$12315 INV_X1
X$6465 \$12315 \$11922 \$12171 VDD \$12563 VSS OAI21_X1
X$6467 \$12089 VSS VDD \$12171 INV_X1
X$6469 \$12173 \$12079 \$12171 \$11360 VSS VDD \$12086 NAND4_X1
X$6470 \$11918 \$12069 VSS VDD \$12173 NAND2_X1
X$6474 \$11790 VSS VDD \$I101706 INV_X2
X$6475 \$9245 VSS VDD \$11790 CLKBUF_X3
X$6477 \$11922 \$12069 VDD VSS \$12174 XNOR2_X1
X$6480 VSS \$11790 \$I99963 \$12303 \$12071 \$9850 VDD DFFR_X1
X$6482 \$12181 \$12176 \$12299 VSS \$12183 VDD AOI21_X1
X$6483 \$10421 \$12177 VDD VSS \$12074 AND2_X1
X$6484 \$12072 \$12074 \$12176 VDD VSS \$12181 HA_X1
X$6491 \$11926 \$12292 VSS VDD \$12290 XOR2_X1
X$6492 \$12176 VSS VDD \$12292 CLKBUF_X1
X$6494 VSS \$11790 \$I99790 \$12177 \$12281 \$9850 VDD DFFR_X1
X$6506 \$3184 VSS VDD \$3294 INV_X1
X$6507 \$3425 \$3411 \$3294 VDD \$3203 VSS OAI21_X1
X$6511 \$3542 VSS VDD \$3078 INV_X1
X$6514 VSS \$3401 \$3185 \$3200 \$3406 \$3186 VDD FA_X1
X$6516 VSS \$3389 \$3401 \$3198 \$3393 \$3067 VDD FA_X1
X$6519 \$3036 VSS VDD \$3425 INV_X1
X$6521 \$3184 \$3036 \$3037 VSS \$3572 VDD AOI21_X1
X$6522 \$3295 \$3541 \$3036 VDD VSS \$3184 HA_X1
X$6523 \$3408 VSS VDD \$3295 INV_X1
X$6528 \$3065 VSS VDD \$3383 INV_X1
X$6529 VSS \$3383 \$3298 \$3365 \$3371 \$3546 VDD FA_X1
X$6530 VSS \$3374 \$3389 \$3195 \$3299 \$3040 VDD FA_X1
X$6536 \$3363 VSS VDD \$3371 INV_X1
X$6539 \$2609 \$1901 VSS VDD \$3359 NAND2_X1
X$6542 \$3359 VSS VDD \$3561 INV_X1
X$6544 VSS \$3320 \$3363 \$3188 \$3324 \$3561 VDD FA_X1
X$6545 \$3357 VSS VDD \$3053 INV_X1
X$6547 VSS \$3548 \$3357 \$3190 \$3302 \$3188 VDD FA_X1
X$6557 \$1904 \$1764 VSS VDD \$3305 NAND2_X1
X$6558 \$3305 VSS VDD \$3324 INV_X1
X$6559 \$3553 VSS VDD \$3320 INV_X1
X$6560 \$2371 \$1743 VSS VDD \$3553 NAND2_X1
X$6577 \$9100 VSS VDD \$10157 INV_X1
X$6583 \$9099 VSS VDD \$I68713 INV_X1
X$6584 \$9334 \$9662 VDD VSS \$10636 XNOR2_X1
X$6585 \$6180 VSS VDD \$9099 CLKBUF_X3
X$6588 \$9810 VSS VDD \$10162 CLKBUF_X1
X$6589 VSS \$9099 \$I99994 \$10375 \$10162 \$8875 VDD DFFR_X1
X$6590 \$7826 \$10375 VDD VSS \$8987 AND2_X1
X$6592 \$10050 VSS VDD \$8444 INV_X1
X$6595 VSS \$7564 \$I100249 \$10052 \$9569 \$8875 VDD DFFR_X1
X$6600 \$10165 VSS VDD \$10164 CLKBUF_X1
X$6605 \$10257 \$10166 VDD VSS \$10460 XNOR2_X1
X$6607 \$10054 \$9966 VDD VSS \$10377 XNOR2_X1
X$6610 \$9812 \$10377 VDD VSS \$10376 XNOR2_X1
X$6611 VSS \$9694 \$10461 \$10547 \$9967 \$9968 VDD FA_X1
X$6612 \$9966 VSS VDD \$9967 INV_X1
X$6616 VSS \$9813 \$9968 \$10263 \$9693 \$10062 VDD FA_X1
X$6619 \$10167 VSS VDD \$9693 INV_X1
X$6621 \$10263 VSS VDD \$10378 INV_X1
X$6623 VSS \$10269 \$10670 \$10470 \$10267 \$10167 VDD FA_X1
X$6625 \$10065 VSS VDD \$10062 INV_X1
X$6626 VSS \$9815 \$10065 \$10267 \$9814 \$9970 VDD FA_X1
X$6627 \$10068 VSS VDD \$9970 INV_X1
X$6628 \$8897 \$8532 VSS VDD \$10068 NAND2_X1
X$6630 \$10072 VSS VDD \$10168 INV_X1
X$6632 \$9972 VSS VDD \$9973 INV_X1
X$6635 VSS \$9822 \$10169 \$10282 \$9825 \$9974 VDD FA_X1
X$6637 VSS \$9977 \$9975 \$10089 \$10086 \$10285 VDD FA_X1
X$6638 VSS \$10100 \$10289 \$11433 \$10089 \$10092 VDD FA_X1
X$6640 \$8350 \$8269 VSS VDD \$9979 NAND2_X1
X$6641 \$9979 VSS VDD \$10097 INV_X1
X$6642 \$9831 \$10097 \$10814 VDD VSS \$10100 HA_X1
X$6643 \$9954 VSS VDD \$9955 CLKBUF_X1
X$6646 \$9119 VSS VDD \$I94153 CLKBUF_X1
X$6647 \$10491 VSS VDD \$10305 CLKBUF_X1
X$6648 \$10102 VSS VDD \$9981 CLKBUF_X1
X$6649 \$10493 VSS VDD \$10113 CLKBUF_X1
X$6650 \$10110 VSS VDD \$10176 CLKBUF_X1
X$6651 \$5493 VSS VDD \$9119 CLKBUF_X3
X$6656 VSS \$9817 \$10269 \$10278 \$10276 \$10168 VDD FA_X1
X$6657 \$10278 VSS VDD \$10678 INV_X1
X$6659 \$9819 VSS VDD \$10682 INV_X1
X$6662 \$9821 VSS VDD \$10476 INV_X1
X$6665 \$10169 VSS VDD \$10379 INV_X1
X$6668 \$10282 VSS VDD \$10950 INV_X1
X$6671 \$9975 VSS VDD \$10554 INV_X1
X$6674 \$8532 \$6756 VSS VDD \$10172 NAND2_X1
X$6675 \$10172 VSS VDD \$10285 INV_X1
X$6676 \$10284 VSS VDD \$10483 INV_X1
X$6680 \$8532 \$8269 VSS VDD \$10384 NAND2_X1
X$6682 VSS \$9119 \$I99797 \$10308 \$10295 \$10386 VDD DFFR_X1
X$6683 \$9750 VSS VDD \$10304 CLKBUF_X1
X$6684 \$10984 VSS VDD \$9275 CLKBUF_X1
X$6685 \$10118 VSS VDD \$10123 CLKBUF_X1
X$6686 \$10120 VSS VDD \$10118 CLKBUF_X1
X$6687 \$10125 VSS VDD \$9960 CLKBUF_X1
X$6688 \$10123 VSS VDD \$10130 CLKBUF_X1
X$6689 \$9595 VSS VDD \$10125 CLKBUF_X1
X$6690 \$10997 VSS VDD \$8822 CLKBUF_X1
X$6691 \$10132 VSS VDD \$10133 CLKBUF_X1
X$6692 \$10133 VSS VDD \$10134 CLKBUF_X1
X$6693 \$10142 VSS VDD \$10332 CLKBUF_X1
X$6694 \$10387 VSS VDD \$9294 CLKBUF_X1
X$6695 \$9986 VSS VDD \$9987 CLKBUF_X1
X$6698 \$10308 VSS VDD \$10507 CLKBUF_X1
X$6699 \$10506 VSS VDD \$10717 CLKBUF_X1
X$6700 VSS \$9119 \$I99939 \$10524 \$10313 \$10386 VDD DFFR_X1
X$6702 \$10330 VSS VDD \$10329 CLKBUF_X1
X$6703 VSS \$9307 \$I99860 \$10571 \$10523 \$6763 VDD DFFR_X1
X$6705 VSS \$9307 \$I100199 \$10147 \$10329 \$6763 VDD DFFR_X1
X$6708 VSS \$8635 \$I100388 \$9359 \$7798 \$6763 VDD DFFR_X1
X$6710 VSS \$10181 \$I100389 \$9990 \$10143 \$6763 VDD DFFR_X1
X$6712 \$9991 VSS VDD \$9989 CLKBUF_X1
X$6713 \$9992 VSS VDD \$10356 CLKBUF_X1
X$6714 \$9784 VSS VDD \$10103 CLKBUF_X1
X$6716 \$10116 VSS VDD \$10119 CLKBUF_X1
X$6717 \$10119 VSS VDD \$9993 CLKBUF_X1
X$6718 \$10392 VSS VDD \$6961 CLKBUF_X1
X$6719 \$9993 VSS VDD \$9994 CLKBUF_X1
X$6720 VSS \$9135 \$I100305 \$10394 \$10103 \$8370 VDD DFFR_X1
X$6722 VSS \$9135 \$I100255 \$10340 \$9996 \$8370 VDD DFFR_X1
X$6724 VSS \$9781 \$I100164 \$10082 \$10090 \$8370 VDD DFFR_X1
X$6725 VSS \$9781 \$I100184 \$9847 \$9999 \$8370 VDD DFFR_X1
X$6727 VSS \$9781 \$I100494 \$9374 \$10076 \$8370 VDD DFFR_X1
X$6728 \$10315 VSS VDD \$10299 CLKBUF_X1
X$6729 \$10306 VSS VDD \$10003 CLKBUF_X1
X$6730 \$10002 VSS VDD \$10075 CLKBUF_X1
X$6731 VSS \$10005 \$I100182 \$10294 \$10003 \$8370 VDD DFFR_X1
X$6732 VSS \$10005 \$I100418 \$10064 \$10954 \$6120 VDD DFFR_X1
X$6733 \$10197 VSS VDD \$9885 CLKBUF_X1
X$6734 \$10006 VSS VDD \$9147 CLKBUF_X1
X$6737 \$10386 VSS VDD \$6763 BUF_X2
X$6738 \$10147 VSS VDD \$10343 CLKBUF_X1
X$6739 VSS \$8635 \$I99889 \$10388 \$10518 \$6763 VDD DFFR_X1
X$6740 VSS \$10181 \$I99894 \$10509 \$10346 \$8370 VDD DFFR_X1
X$6742 \$10183 VSS VDD \$10389 CLKBUF_X1
X$6744 \$9989 VSS VDD \$9992 CLKBUF_X1
X$6745 \$9603 VSS VDD \$10106 CLKBUF_X1
X$6746 \$10361 VSS VDD \$10775 CLKBUF_X1
X$6747 VSS \$9135 \$I100106 \$10490 \$10504 \$6763 VDD DFFR_X1
X$6748 VSS \$9135 \$10488 \$10777 \$10360 \$8370 VDD DFFR_X1
X$6750 VSS \$9135 \$I100125 \$10188 \$10349 \$8370 VDD DFFR_X1
X$6751 \$10189 VSS VDD \$7605 CLKBUF_X1
X$6752 \$10340 VSS VDD \$10397 CLKBUF_X1
X$6753 \$10338 VSS VDD \$9920 CLKBUF_X1
X$6754 \$10397 VSS VDD \$10338 CLKBUF_X1
X$6755 \$9840 VSS VDD \$10190 CLKBUF_X1
X$6757 \$10191 VSS VDD \$10478 CLKBUF_X1
X$6759 \$9943 VSS VDD \$9781 CLKBUF_X3
X$6760 \$10082 VSS VDD \$9905 CLKBUF_X1
X$6761 \$10083 VSS VDD \$10324 CLKBUF_X1
X$6762 \$10192 VSS VDD \$10080 CLKBUF_X1
X$6763 \$10979 VSS VDD \$9144 CLKBUF_X1
X$6764 \$10322 VSS VDD \$10319 CLKBUF_X1
X$6765 \$10473 VSS VDD \$9893 CLKBUF_X1
X$6766 \$10319 VSS VDD \$10306 CLKBUF_X1
X$6770 \$10310 VSS VDD \$10312 CLKBUF_X1
X$6771 \$10471 VSS VDD \$10316 CLKBUF_X1
X$6772 \$10316 VSS VDD \$10310 CLKBUF_X1
X$6773 \$10312 VSS VDD \$10193 CLKBUF_X1
X$6774 \$10469 VSS VDD \$10473 CLKBUF_X1
X$6775 \$10193 VSS VDD \$10002 CLKBUF_X1
X$6777 \$9245 VSS VDD \$10005 CLKBUF_X3
X$6778 \$10699 VSS VDD \$10959 CLKBUF_X1
X$6780 VSS \$10005 \$I100075 \$10466 \$10299 \$6120 VDD DFFR_X1
X$6781 \$10294 VSS VDD \$10197 CLKBUF_X1
X$6783 \$10465 VSS VDD \$10400 CLKBUF_X1
X$6785 \$10401 VSS VDD \$10402 CLKBUF_X1
X$6786 \$10064 VSS VDD \$9844 CLKBUF_X1
X$6787 VSS \$10007 \$I100540 \$6379 \$10058 \$6120 VDD DFFR_X1
X$6788 VSS \$10007 \$I100394 \$10199 \$10059 \$6120 VDD DFFR_X1
X$6790 \$10402 VSS VDD \$10403 CLKBUF_X1
X$6791 \$9736 VSS VDD \$10459 CLKBUF_X1
X$6792 \$10403 VSS VDD \$10279 CLKBUF_X1
X$6793 \$10279 VSS VDD \$10059 CLKBUF_X1
X$6794 \$10404 VSS VDD \$9882 CLKBUF_X1
X$6796 \$10270 VSS VDD \$10406 CLKBUF_X1
X$6797 \$10199 VSS VDD \$10270 CLKBUF_X1
X$6798 \$10406 VSS VDD \$10405 CLKBUF_X1
X$6799 \$10407 VSS VDD \$10265 CLKBUF_X1
X$6800 \$10265 VSS VDD \$10058 CLKBUF_X1
X$6803 \$10009 VSS VDD \$10010 INV_X1
X$6804 \$9847 \$6379 VSS VDD \$10009 NAND2_X1
X$6806 \$9153 \$6381 VSS VDD \$10012 NAND2_X1
X$6807 \$10012 VSS VDD \$10253 INV_X1
X$6812 \$10010 \$10453 \$10250 VDD VSS \$10411 HA_X1
X$6815 \$6381 \$9152 VSS VDD \$10412 NOR2_X1
X$6816 VSS \$10253 \$10898 \$10446 \$9391 \$10449 VDD FA_X1
X$6817 \$9245 VSS VDD \$10007 CLKBUF_X3
X$6818 \$10007 VSS VDD \$I101754 INV_X4
X$6819 \$9692 VSS VDD \$10648 INV_X1
X$6820 \$10046 VSS VDD \$10649 INV_X1
X$6823 \$9685 VSS VDD \$10642 INV_X1
X$6827 \$10200 VSS VDD \$10442 INV_X1
X$6830 VSS \$9405 \$10415 \$10416 \$10242 \$9411 VDD FA_X1
X$6832 \$10015 VSS VDD \$10014 INV_X1
X$6833 \$10037 VSS VDD \$10242 INV_X1
X$6838 VSS \$10007 \$I100275 \$10016 \$9397 \$9850 VDD DFFR_X1
X$6840 VSS \$10207 \$10017 \$10020 \$10213 \$10030 VDD FA_X1
X$6841 VSS \$9627 \$I100192 \$10422 \$10206 \$9850 VDD DFFR_X1
X$6850 VSS \$10007 \$I99888 \$10202 \$10228 \$9850 VDD DFFR_X1
X$6851 \$10216 \$10419 \$10417 VDD VSS \$10425 HA_X1
X$6852 \$9245 VSS VDD \$9627 CLKBUF_X3
X$6853 \$9852 \$10426 \$10627 VDD VSS \$10433 HA_X1
X$6854 \$9636 VSS VDD \$10216 CLKBUF_X1
X$6855 \$9628 VSS VDD \$10204 CLKBUF_X1
X$6856 \$9629 VSS VDD \$10206 CLKBUF_X1
X$6857 \$10425 VSS VDD \$10207 INV_X1
X$6930 xin[1] VSS VDD \$15890 BUF_X1
X$6936 \$16180 VSS VDD \$16106 CLKBUF_X1
X$6937 \$16106 VSS VDD \$15891 CLKBUF_X1
X$6938 \$15670 VSS VDD \$16180 CLKBUF_X1
X$6944 \$16107 VSS VDD \$16372 INV_X1
X$6946 \$15983 VSS VDD \$16375 INV_X1
X$6949 \$16181 \$15978 \$16108 VDD VSS \$16728 HA_X1
X$6950 \$16187 VSS VDD \$16109 INV_X1
X$6954 \$15893 VSS VDD \$16189 INV_X1
X$6959 \$15892 VSS VDD \$16311 INV_X1
X$6963 \$15991 VSS VDD \$16388 INV_X1
X$6964 \$16189 \$16388 \$16389 VDD VSS \$16390 HA_X1
X$6966 \$15896 \$15998 \$15895 VDD VSS \$16110 HA_X1
X$6967 \$15895 VSS VDD \$16192 INV_X1
X$6968 \$16192 \$15899 \$15898 VDD \$15897 VSS OAI21_X1
X$6969 \$16110 VSS VDD \$15898 INV_X1
X$6973 \$15899 \$15895 VDD VSS \$16196 XNOR2_X1
X$6978 \$15902 VSS VDD \$16115 CLKBUF_X1
X$6982 \$15385 \$13414 VSS VDD \$16116 NAND2_X1
X$6983 \$16116 VSS VDD \$16206 INV_X1
X$6984 \$15458 \$13098 VSS VDD \$16117 NAND2_X1
X$6985 \$16117 VSS VDD \$15906 INV_X1
X$6986 \$16206 \$15906 \$16214 VDD VSS \$16118 HA_X1
X$6992 \$16318 VSS VDD \$16112 CLKBUF_X1
X$6993 \$16113 VSS VDD \$16114 CLKBUF_X1
X$6996 VSS \$16319 \$I100098 \$16412 \$16196 \$12319 VDD DFFR_X1
X$6997 VSS \$16319 \$I100146 \$16215 \$16200 \$12319 VDD DFFR_X1
X$7001 \$16419 VSS VDD \$16207 CLKBUF_X1
X$7005 \$15458 \$13041 VSS VDD \$16120 NAND2_X1
X$7007 \$16210 VSS VDD \$15909 INV_X1
X$7008 \$16120 VSS VDD \$16023 INV_X1
X$7010 VSS \$16214 \$16031 \$15910 \$16217 \$16025 VDD FA_X1
X$7011 \$16427 VSS VDD \$16029 INV_X1
X$7014 \$15388 \$13041 VSS VDD \$16322 NAND2_X1
X$7015 \$16207 VSS VDD \$16213 CLKBUF_X1
X$7016 \$16323 \$13181 VSS VDD \$16210 NAND2_X1
X$7019 \$16213 VSS VDD \$16228 CLKBUF_X1
X$7022 VSS \$15911 \$16471 \$16227 \$16325 \$16224 VDD FA_X1
X$7024 \$16031 VSS VDD \$16224 INV_X1
X$7026 \$16036 VSS VDD \$16233 CLKBUF_X1
X$7035 \$16227 VSS VDD \$16432 INV_X1
X$7036 \$16037 \$16432 \$16230 VDD VSS \$16234 HA_X1
X$7037 \$16433 \$16122 VSS VDD \$16326 NAND2_X1
X$7038 \$16234 VSS VDD \$16433 INV_X1
X$7040 VSS \$14244 \$I100449 \$16123 \$16233 \$15541 VDD DFFR_X1
X$7044 VSS \$14990 \$I100453 \$16052 \$16245 \$15181 VDD DFFR_X1
X$7045 VSS \$14990 \$I100319 \$16130 \$16127 \$15181 VDD DFFR_X1
X$7046 \$16131 VSS VDD \$15917 CLKBUF_X1
X$7047 \$16132 \$15699 \$15915 VSS VDD \$15696 NAND3_X1
X$7048 \$15698 \$15916 VSS VDD \$16132 NAND2_X1
X$7052 \$16123 VSS VDD \$16238 CLKBUF_X1
X$7053 \$16238 VSS VDD \$16241 CLKBUF_X1
X$7054 \$16241 VSS VDD \$16243 CLKBUF_X1
X$7055 \$16243 VSS VDD \$16239 CLKBUF_X1
X$7056 \$16239 VSS VDD \$16244 CLKBUF_X1
X$7057 \$16244 VSS VDD \$16245 CLKBUF_X1
X$7058 \$16615 VSS VDD \$16331 CLKBUF_X1
X$7059 \$16052 VSS VDD \$16839 CLKBUF_X1
X$7060 \$16053 VSS VDD \$15913 CLKBUF_X1
X$7062 \$16250 VSS VDD \$16618 CLKBUF_X1
X$7063 VSS \$14990 \$I99912 \$16443 \$16475 \$15181 VDD DFFR_X1
X$7064 \$15916 VSS VDD \$15547 CLKBUF_X1
X$7065 \$16130 VSS VDD \$16131 CLKBUF_X1
X$7068 \$16133 VSS VDD \$16437 CLKBUF_X1
X$7070 \$15849 VSS VDD \$16066 CLKBUF_X1
X$7072 \$16134 VSS VDD \$16068 CLKBUF_X1
X$7074 VSS \$14252 \$I100284 \$16137 \$16262 \$15181 VDD DFFR_X1
X$7076 \$15923 VSS VDD \$16266 CLKBUF_X1
X$7079 VSS \$14252 \$I100089 \$16335 \$16334 \$15181 VDD DFFR_X1
X$7081 \$16266 VSS VDD \$16081 CLKBUF_X1
X$7082 \$15924 VSS VDD \$15001 CLKBUF_X1
X$7083 \$16080 VSS VDD \$15923 CLKBUF_X1
X$7087 \$16138 VSS VDD \$16140 CLKBUF_X1
X$7090 VSS \$15509 \$I99796 \$16337 \$16336 \$15181 VDD DFFR_X1
X$7091 VSS \$15509 \$I100066 \$16340 \$16338 \$15181 VDD DFFR_X1
X$7092 \$15926 VSS VDD \$15005 CLKBUF_X1
X$7094 VSS \$15509 \$I100203 \$16273 \$16142 \$15181 VDD DFFR_X1
X$7095 VSS \$15509 \$I100339 \$15190 \$15929 \$15181 VDD DFFR_X1
X$7097 \$16272 VSS VDD \$16142 CLKBUF_X1
X$7098 \$16341 VSS VDD \$16274 CLKBUF_X1
X$7099 \$16274 VSS VDD \$16272 CLKBUF_X1
X$7100 \$16273 VSS VDD \$16277 CLKBUF_X1
X$7101 \$16277 VSS VDD \$16423 CLKBUF_X1
X$7102 \$16275 VSS VDD \$16143 CLKBUF_X1
X$7103 \$16279 VSS VDD \$15929 CLKBUF_X1
X$7104 \$16143 VSS VDD \$16279 CLKBUF_X1
X$7105 \$16423 VSS VDD \$16275 CLKBUF_X1
X$7107 \$15704 VSS VDD \$17003 CLKBUF_X1
X$7109 VSS \$15189 \$I100523 \$16145 \$16421 \$15181 VDD DFFR_X1
X$7113 \$15160 VSS VDD \$16144 CLKBUF_X1
X$7116 \$16145 VSS VDD \$16284 CLKBUF_X1
X$7117 \$15401 VSS VDD \$16343 CLKBUF_X1
X$7118 \$16284 VSS VDD \$16146 CLKBUF_X1
X$7119 \$16294 VSS VDD \$16150 CLKBUF_X1
X$7120 VSS \$15007 \$I100303 \$16345 \$16287 \$15181 VDD DFFR_X1
X$7122 VSS \$15406 \$I100206 \$16153 \$16574 \$15181 VDD DFFR_X1
X$7126 \$16285 VSS VDD \$16148 CLKBUF_X1
X$7127 \$16146 VSS VDD \$16285 CLKBUF_X1
X$7128 \$16147 VSS VDD \$16149 CLKBUF_X1
X$7129 \$16148 VSS VDD \$16147 CLKBUF_X1
X$7130 \$16149 VSS VDD \$16287 CLKBUF_X1
X$7131 \$16289 VSS VDD \$16417 CLKBUF_X1
X$7132 \$16150 VSS VDD \$15932 CLKBUF_X1
X$7133 \$15560 VSS VDD \$I101748 INV_X4
X$7134 \$16077 VSS VDD \$16295 CLKBUF_X1
X$7135 \$16417 VSS VDD \$16294 CLKBUF_X1
X$7136 \$15194 VSS VDD \$16491 CLKBUF_X1
X$7141 \$16153 VSS VDD \$16300 CLKBUF_X1
X$7142 \$15565 VSS VDD \$16689 CLKBUF_X1
X$7144 \$16300 VSS VDD \$16302 CLKBUF_X1
X$7146 VSS \$15406 \$I100298 \$16348 \$16154 \$15181 VDD DFFR_X1
X$7149 VSS \$15933 \$I100423 \$16156 \$15934 \$15181 VDD DFFR_X1
X$7150 \$15938 VSS VDD \$16286 CLKBUF_X1
X$7151 \$16282 VSS VDD \$15937 CLKBUF_X1
X$7152 \$15939 VSS VDD \$16349 CLKBUF_X1
X$7153 \$16286 VSS VDD \$16282 CLKBUF_X1
X$7158 \$16302 VSS VDD \$16304 CLKBUF_X1
X$7159 \$16304 VSS VDD \$16305 CLKBUF_X1
X$7160 \$16347 VSS VDD \$16154 CLKBUF_X1
X$7162 \$16305 VSS VDD \$16308 CLKBUF_X1
X$7166 \$16408 VSS VDD \$16306 CLKBUF_X1
X$7167 \$16308 VSS VDD \$15934 CLKBUF_X1
X$7168 \$16301 VSS VDD \$16059 CLKBUF_X1
X$7169 \$16306 VSS VDD \$16301 CLKBUF_X1
X$7172 VSS \$15933 \$I99823 \$16157 \$14877 \$15181 VDD DFFR_X1
X$7176 \$16280 \$16158 VSS VDD \$15411 NAND2_X1
X$7179 \$16351 VSS VDD \$16280 INV_X1
X$7181 \$15941 VSS VDD \$16399 INV_X1
X$7184 \$15190 \$13989 VSS VDD \$16159 NAND2_X1
X$7185 \$16159 VSS VDD \$16269 INV_X1
X$7187 \$16259 VSS VDD \$16035 INV_X1
X$7188 \$16269 \$16035 \$14543 VDD VSS \$14323 HA_X1
X$7194 \$14543 VSS VDD \$16353 INV_X1
X$7196 \$16160 VSS VDD \$15948 INV_X1
X$7197 \$14700 \$13679 VSS VDD \$16160 NAND2_X1
X$7200 \$15190 \$13571 VSS VDD \$16541 NAND2_X1
X$7202 \$15151 \$13989 VSS VDD \$16259 NAND2_X1
X$7206 VSS \$16164 \$16531 \$16395 \$16249 \$16165 VDD FA_X1
X$7207 \$14884 \$13679 VSS VDD \$16163 NAND2_X1
X$7209 \$16163 VSS VDD \$16165 INV_X1
X$7211 \$14273 \$13680 VSS VDD \$16013 NAND2_X1
X$7212 \$16013 VSS VDD \$16249 INV_X1
X$7214 \$14273 \$13398 VSS VDD \$16168 NAND2_X1
X$7218 VSS \$15958 \$16945 \$16357 \$15956 \$16002 VDD FA_X1
X$7222 \$15151 \$13679 VSS VDD \$16359 NAND2_X1
X$7225 \$15151 \$13872 VSS VDD \$16194 NAND2_X1
X$7229 \$14884 \$13872 VSS VDD \$16500 NAND2_X1
X$7230 \$16168 VSS VDD \$16355 INV_X1
X$7232 \$14700 \$13680 VSS VDD \$16503 NAND2_X1
X$7234 \$16226 VSS VDD \$16356 INV_X1
X$7237 \$15190 \$13679 VSS VDD \$16519 NAND2_X1
X$7241 \$15767 VSS VDD \$16358 INV_X1
X$7244 \$15190 \$13872 VSS VDD \$16171 NAND2_X1
X$7246 \$15190 \$13680 VSS VDD \$16379 NAND2_X1
X$7247 \$16379 VSS VDD \$16383 INV_X1
X$7248 \$16194 VSS VDD \$16360 INV_X1
X$7250 \$15190 \$13398 VSS VDD \$16173 NAND2_X1
X$7252 \$15151 \$13680 VSS VDD \$16174 NAND2_X1
X$7254 \$16174 VSS VDD \$16175 INV_X1
X$7257 \$15732 \$16183 \$15968 VDD VSS \$16176 HA_X1
X$7267 \$16173 VSS VDD \$16370 INV_X1
X$7268 \$16175 \$16370 \$16183 VDD VSS \$16369 HA_X1
X$7269 VSS \$16377 \$16717 \$16179 \$15965 \$16369 VDD FA_X1
X$7270 \$15971 \$16179 \$16361 VDD VSS \$16366 HA_X1
X$7285 \$4764 VSS VDD \$4765 CLKBUF_X1
X$7286 \$5015 VSS VDD \$5008 CLKBUF_X1
X$7287 \$5008 VSS VDD \$4764 CLKBUF_X1
X$7288 VSS \$4480 \$I100343 \$4941 \$4770 \$3006 VDD DFFR_X1
X$7289 \$5017 VSS VDD \$5018 CLKBUF_X1
X$7290 \$4686 VSS VDD \$4327 CLKBUF_X1
X$7293 \$5020 VSS VDD \$4770 CLKBUF_X1
X$7294 VSS \$4480 \$I99930 \$5171 \$5224 \$3006 VDD DFFR_X1
X$7298 \$1692 VSS VDD \$4480 CLKBUF_X3
X$7299 \$5018 VSS VDD \$5015 CLKBUF_X1
X$7300 \$4941 VSS VDD \$5017 CLKBUF_X1
X$7301 \$5232 VSS VDD \$5231 CLKBUF_X1
X$7302 \$5226 VSS VDD \$5020 CLKBUF_X1
X$7304 \$4787 VSS VDD \$4687 CLKBUF_X1
X$7305 \$3904 VSS VDD \$3903 CLKBUF_X1
X$7306 \$4790 VSS VDD \$4942 CLKBUF_X1
X$7307 \$4578 VSS VDD \$4789 CLKBUF_X1
X$7308 VSS \$4944 \$I100342 \$4489 \$4943 \$1304 VDD DFFR_X1
X$7309 VSS \$4944 \$I100289 \$4948 \$4795 \$1304 VDD DFFR_X1
X$7311 \$5239 VSS VDD \$4943 CLKBUF_X1
X$7312 \$4942 VSS VDD \$5239 CLKBUF_X1
X$7313 \$5037 VSS VDD \$5035 CLKBUF_X1
X$7314 \$5962 VSS VDD \$5446 CLKBUF_X1
X$7315 \$5242 VSS VDD \$5248 CLKBUF_X1
X$7316 \$4945 VSS VDD \$5242 CLKBUF_X1
X$7317 \$5243 VSS VDD \$5173 CLKBUF_X1
X$7319 \$1692 VSS VDD \$4944 CLKBUF_X3
X$7321 \$5035 VSS VDD \$5041 CLKBUF_X1
X$7323 \$5253 VSS VDD \$5175 CLKBUF_X1
X$7325 \$4249 VSS VDD \$5034 CLKBUF_X1
X$7326 \$4948 VSS VDD \$4688 CLKBUF_X1
X$7327 \$4251 VSS VDD \$4584 CLKBUF_X1
X$7328 VSS \$4944 \$I100290 \$4950 \$4692 \$1304 VDD DFFR_X1
X$7329 \$4689 VSS VDD \$4691 CLKBUF_X1
X$7330 VSS \$4954 \$I100341 \$4952 \$4951 \$1304 VDD DFFR_X1
X$7331 \$4953 VSS VDD \$5058 CLKBUF_X1
X$7332 \$5058 VSS VDD \$5055 CLKBUF_X1
X$7334 \$5256 VSS VDD \$5259 CLKBUF_X1
X$7335 \$4691 VSS VDD \$5053 CLKBUF_X1
X$7336 \$5176 VSS VDD \$4692 CLKBUF_X1
X$7337 \$5259 VSS VDD \$5176 CLKBUF_X1
X$7338 \$5053 VSS VDD \$5256 CLKBUF_X1
X$7340 \$5177 VSS VDD \$5178 CLKBUF_X1
X$7341 \$4950 VSS VDD \$5177 CLKBUF_X1
X$7342 \$5178 VSS VDD \$5179 CLKBUF_X1
X$7343 \$5180 VSS VDD \$5260 CLKBUF_X1
X$7344 \$5260 VSS VDD \$4951 CLKBUF_X1
X$7346 \$4952 VSS VDD \$4953 CLKBUF_X1
X$7347 \$5055 VSS VDD \$5181 CLKBUF_X1
X$7348 \$5262 VSS VDD \$5265 CLKBUF_X1
X$7349 VSS \$4954 \$I99832 \$5272 \$5265 \$3006 VDD DFFR_X1
X$7350 \$4822 VSS VDD \$4604 CLKBUF_X1
X$7352 \$4816 VSS VDD \$5066 CLKBUF_X1
X$7353 \$4382 VSS VDD \$4816 CLKBUF_X1
X$7354 \$4955 VSS VDD \$5064 CLKBUF_X1
X$7355 \$4821 VSS VDD \$5270 CLKBUF_X1
X$7356 \$5066 VSS VDD \$4821 CLKBUF_X1
X$7357 \$4837 VSS VDD \$4827 CLKBUF_X1
X$7358 \$1692 VSS VDD \$4260 CLKBUF_X3
X$7360 VSS \$4260 \$I99842 \$4500 \$5270 \$3833 VDD DFFR_X1
X$7361 \$4833 VSS VDD \$5079 CLKBUF_X1
X$7362 \$4827 VSS VDD \$4502 CLKBUF_X1
X$7363 \$5081 VSS VDD \$4833 CLKBUF_X1
X$7364 \$4848 VSS VDD \$4834 CLKBUF_X1
X$7365 \$5079 VSS VDD \$4835 CLKBUF_X1
X$7366 \$4846 VSS VDD \$4844 CLKBUF_X1
X$7367 \$4698 VSS VDD \$4848 CLKBUF_X1
X$7368 \$4411 VSS VDD \$5283 CLKBUF_X1
X$7369 \$5085 VSS VDD \$4856 CLKBUF_X1
X$7370 VSS \$3628 \$I100302 \$4699 \$4854 \$3833 VDD DFFR_X1
X$7371 VSS \$4506 \$I100285 \$4507 \$4864 \$3833 VDD DFFR_X1
X$7372 \$4701 VSS VDD \$4966 CLKBUF_X1
X$7374 VSS \$4260 \$I99794 \$5081 \$4697 \$3833 VDD DFFR_X1
X$7375 VSS \$3628 \$I99934 \$5185 \$5277 \$3833 VDD DFFR_X1
X$7377 VSS \$4506 \$I99795 \$5305 \$5295 \$3833 VDD DFFR_X1
X$7378 VSS \$4506 \$I99892 \$5189 \$5309 \$3833 VDD DFFR_X1
X$7379 \$4702 VSS VDD \$4508 CLKBUF_X1
X$7380 \$5105 VSS VDD \$4870 CLKBUF_X1
X$7381 \$4875 VSS VDD \$5105 CLKBUF_X1
X$7383 \$4703 VSS VDD \$4968 CLKBUF_X1
X$7385 \$4510 VSS VDD \$I101712 INV_X2
X$7386 \$191 VSS VDD \$4510 CLKBUF_X3
X$7387 \$4705 VSS VDD \$4706 CLKBUF_X1
X$7391 \$4707 VSS VDD \$4021 CLKBUF_X1
X$7392 \$4970 VSS VDD \$4894 INV_X1
X$7393 \$5193 VSS VDD \$4709 INV_X1
X$7396 \$4710 VSS VDD \$4513 INV_X1
X$7399 \$4665 VSS VDD \$5126 INV_X1
X$7400 \$5126 \$4711 VSS \$4901 VDD NAND2_X4
X$7403 \$4917 \$4712 VSS \$4711 VDD NAND2_X4
X$7407 \$4715 VSS VDD \$4716 INV_X1
X$7408 \$5147 \$4716 \$5153 VDD \$5145 VSS OAI21_X1
X$7411 \$4929 VSS VDD \$5153 INV_X1
X$7413 VSS \$4510 \$I100036 \$5325 \$5318 \$3833 VDD DFFR_X1
X$7416 \$5329 VSS VDD \$5326 CLKBUF_X1
X$7422 \$5356 VSS VDD \$4708 INV_X1
X$7426 \$1984 VSS VDD \$5194 CLKBUF_X1
X$7427 \$20 \$5343 \$5344 VSS VDD \$2588 NOR3_X1
X$7431 \$5145 VSS VDD \$5354 INV_X1
X$7433 \$5144 \$4715 VDD VSS \$4970 XNOR2_X1
X$7434 \$4973 VSS VDD \$5361 INV_X1
X$7435 \$5361 \$5199 \$5147 VDD \$5144 VSS OAI21_X1
X$7436 \$4973 \$4715 VSS VDD \$5200 NAND2_X1
X$7438 \$5349 VSS VDD \$5147 INV_X1
X$7440 \$5159 VSS VDD \$5398 CLKBUF_X1
X$7441 \$4936 \$4717 \$4715 VDD VSS \$4929 HA_X1
X$7443 \$5161 VSS VDD \$5159 CLKBUF_X1
X$7445 \$4680 VSS VDD \$5558 CLKBUF_X1
X$7448 \$4975 \$4938 \$4718 VDD \$4522 VSS OAI21_X1
X$7449 \$4523 VSS VDD \$4938 INV_X1
X$7450 \$5202 \$4523 \$4281 \$4282 VDD VSS \$5155 AND4_X1
X$7454 \$5334 \$5350 \$4973 VDD VSS \$5349 HA_X1
X$7456 \$5348 VSS VDD \$5350 INV_X1
X$7460 \$5201 \$4523 VDD VSS \$5559 XNOR2_X1
X$7461 \$4523 \$5201 VSS VDD \$4719 NAND2_X1
X$7462 \$4975 \$5204 VSS VDD \$5201 NAND2_X1
X$7464 \$5337 VSS VDD \$4975 INV_X1
X$7465 \$5163 \$4720 \$5202 VDD VSS \$5337 HA_X1
X$7466 \$5335 VSS VDD \$5163 INV_X1
X$7469 VSS \$5148 \$5335 \$5678 \$5331 \$4977 VDD FA_X1
X$7470 \$3931 VSS VDD \$5331 INV_X1
X$7474 VSS \$4528 \$4977 \$5140 \$5154 \$4721 VDD FA_X1
X$7477 \$5330 VSS VDD \$5148 INV_X1
X$7478 VSS \$5135 \$5330 \$5564 \$5137 \$5205 VDD FA_X1
X$7480 \$5140 VSS VDD \$5205 INV_X1
X$7482 \$5128 VSS VDD \$4915 CLKBUF_X1
X$7483 \$3603 \$4529 \$4978 VDD VSS \$5135 HA_X1
X$7485 VSS \$4530 \$4979 \$4981 \$4531 \$4908 VDD FA_X1
X$7486 \$4723 \$4724 \$5123 VDD VSS \$4908 HA_X1
X$7487 \$5123 VSS VDD \$4982 INV_X1
X$7488 \$5116 VSS VDD \$5316 CLKBUF_X1
X$7489 \$4217 VSS VDD \$5319 INV_X1
X$7492 \$4978 VSS VDD \$5129 INV_X1
X$7495 \$4979 VSS VDD \$5592 INV_X1
X$7496 VSS \$5125 \$5206 \$5207 \$5129 \$5323 VDD FA_X1
X$7497 \$5316 VSS VDD \$5128 CLKBUF_X1
X$7498 \$4902 VSS VDD \$5125 INV_X1
X$7499 \$4981 VSS VDD \$5323 INV_X1
X$7501 VSS \$4982 \$5208 \$5210 \$5319 \$5209 VDD FA_X1
X$7503 \$5304 VSS VDD \$5209 INV_X1
X$7515 VSS \$15226 \$15582 \$16107 \$14381 \$15225 VDD FA_X1
X$7521 VSS \$15161 \$15522 \$15425 \$14005 \$13947 VDD FA_X1
X$7522 \$14005 VSS VDD \$15428 INV_X1
X$7525 \$15425 VSS VDD \$15590 INV_X1
X$7526 VSS \$14674 \$15673 \$15674 \$15375 \$15590 VDD FA_X1
X$7528 VSS \$14226 \$15525 \$15432 \$15430 \$12525 VDD FA_X1
X$7529 \$14968 VSS VDD \$15526 INV_X1
X$7531 \$15432 VSS VDD \$15241 INV_X1
X$7533 VSS \$15241 \$15162 \$15378 \$14509 \$15061 VDD FA_X1
X$7541 VSS \$14925 \$15527 \$15439 \$15435 \$15378 VDD FA_X1
X$7542 \$15439 VSS VDD \$15438 INV_X1
X$7544 VSS \$15442 \$16000 \$15440 \$15438 \$15600 VDD FA_X1
X$7545 \$15440 VSS VDD \$15602 INV_X1
X$7548 \$15380 \$15602 \$15678 VDD VSS \$15529 HA_X1
X$7550 \$13150 VSS VDD \$I101752 INV_X4
X$7551 \$15254 \$13090 \$15257 VDD \$15164 VSS OAI21_X1
X$7552 \$15163 VSS VDD \$15254 INV_X1
X$7553 \$13090 \$15163 VDD VSS \$16111 XNOR2_X1
X$7556 VSS \$15449 \$I99887 \$15780 \$15531 \$12319 VDD DFFR_X1
X$7557 \$15165 VSS VDD \$15166 CLKBUF_X1
X$7561 VSS \$15449 \$I99957 \$15622 \$15533 \$12319 VDD DFFR_X1
X$7563 \$15167 VSS VDD \$15168 INV_X1
X$7565 \$15169 VSS VDD \$15170 CLKBUF_X1
X$7567 \$15171 VSS VDD \$15268 CLKBUF_X1
X$7568 VSS \$14238 \$I100250 \$14982 \$15268 \$12319 VDD DFFR_X1
X$7571 VSS \$14238 \$I99910 \$15458 \$15534 \$12319 VDD DFFR_X1
X$7574 \$14982 VSS VDD \$15272 CLKBUF_X1
X$7578 \$15277 VSS VDD \$15282 INV_X1
X$7579 \$15174 \$15388 \$13181 VSS VDD \$15277 NAND3_X1
X$7580 \$15282 \$15175 \$15389 VDD VSS \$15475 HA_X1
X$7587 \$15385 \$13041 VSS VDD \$15386 NAND2_X1
X$7588 \$15386 VSS VDD \$15468 INV_X1
X$7591 \$15537 \$15385 \$13181 VDD VSS \$15472 AND3_X1
X$7592 \$15468 \$15537 \$15639 VDD VSS \$15538 HA_X1
X$7596 \$15472 \$15639 \$15174 VDD VSS \$15390 HA_X1
X$7597 \$15389 \$15390 VSS VDD \$15473 NAND2_X1
X$7599 \$15475 VSS VDD \$15476 INV_X1
X$7600 \$15476 \$15473 VSS VDD \$15540 NAND2_X1
X$7602 \$2886 VSS VDD \$12743 CLKBUF_X3
X$7603 \$12743 VSS VDD \$I101766 INV_X4
X$7607 \$15693 VSS VDD \$15656 CLKBUF_X1
X$7608 \$15655 VSS VDD \$15178 CLKBUF_X1
X$7609 \$15179 VSS VDD \$15542 CLKBUF_X1
X$7610 VSS \$14244 \$I100336 \$15182 \$15180 \$15181 VDD DFFR_X1
X$7612 VSS \$14990 \$I100392 \$15489 \$15546 \$15181 VDD DFFR_X1
X$7613 \$15488 VSS VDD \$15302 CLKBUF_X1
X$7614 \$15302 VSS VDD \$15185 CLKBUF_X1
X$7616 VSS \$14252 \$I100376 \$15316 \$15305 \$15181 VDD DFFR_X1
X$7619 VSS \$14990 \$I99831 \$15654 \$15477 \$15541 VDD DFFR_X1
X$7620 VSS \$14244 \$I99813 \$15545 \$15660 \$15181 VDD DFFR_X1
X$7621 \$15665 \$15668 \$15543 VDD VSS \$15666 HA_X1
X$7622 \$15299 \$15547 VDD VSS \$15393 XNOR2_X1
X$7624 \$15548 VSS VDD \$15485 CLKBUF_X1
X$7625 \$15485 VSS VDD \$15487 CLKBUF_X1
X$7626 \$15487 VSS VDD \$15490 CLKBUF_X1
X$7627 \$15489 VSS VDD \$15183 CLKBUF_X1
X$7628 \$15184 VSS VDD \$15488 CLKBUF_X1
X$7629 \$15490 VSS VDD \$15305 CLKBUF_X1
X$7630 \$14252 VSS VDD \$I92554 CLKBUF_X1
X$7631 \$15394 \$15395 VSS VDD \$14865 XOR2_X1
X$7632 \$12743 VSS VDD \$14252 CLKBUF_X3
X$7633 \$15553 \$15551 \$15394 VSS \$15396 VDD AOI21_X1
X$7635 \$15499 VSS VDD \$15502 CLKBUF_X1
X$7637 \$15316 VSS VDD \$15188 CLKBUF_X1
X$7639 \$15188 VSS VDD \$15499 CLKBUF_X1
X$7640 \$15502 VSS VDD \$15556 CLKBUF_X1
X$7641 \$15650 VSS VDD \$15504 CLKBUF_X1
X$7642 VSS \$15509 \$I99916 \$15506 \$15504 \$15181 VDD DFFR_X1
X$7644 \$15558 VSS VDD \$15003 INV_X1
X$7647 \$15322 VSS VDD \$14953 INV_X1
X$7652 VSS \$15509 \$I99936 \$15641 \$15927 \$15181 VDD DFFR_X1
X$7654 VSS \$15189 \$I100316 \$15328 \$15636 \$15181 VDD DFFR_X1
X$7656 \$15328 VSS VDD \$15634 CLKBUF_X1
X$7657 VSS \$15189 \$I99976 \$15704 \$14836 \$15181 VDD DFFR_X1
X$7658 \$15335 VSS VDD \$15339 CLKBUF_X1
X$7659 VSS \$15189 \$I100329 \$15400 \$15508 \$15181 VDD DFFR_X1
X$7662 VSS \$15007 \$I100272 \$13515 \$15346 \$15181 VDD DFFR_X1
X$7663 \$15006 VSS VDD \$15355 CLKBUF_X1
X$7664 \$15355 VSS VDD \$15357 CLKBUF_X1
X$7666 VSS \$15007 \$I100425 \$15565 \$14539 \$15181 VDD DFFR_X1
X$7668 \$15514 VSS VDD \$15513 CLKBUF_X1
X$7670 \$15513 VSS VDD \$15335 CLKBUF_X1
X$7671 \$15505 VSS VDD \$15508 CLKBUF_X1
X$7672 \$15630 VSS VDD \$15505 CLKBUF_X1
X$7674 \$15400 VSS VDD \$15503 CLKBUF_X1
X$7675 \$15503 VSS VDD \$15627 CLKBUF_X1
X$7676 \$15494 VSS VDD \$15402 CLKBUF_X1
X$7677 \$15627 VSS VDD \$15494 CLKBUF_X1
X$7678 \$15486 VSS VDD \$15404 CLKBUF_X1
X$7679 \$15402 VSS VDD \$15486 CLKBUF_X1
X$7680 \$15404 VSS VDD \$15346 CLKBUF_X1
X$7681 \$15007 VSS VDD \$I92714 CLKBUF_X1
X$7682 \$9943 VSS VDD \$15007 CLKBUF_X3
X$7683 VSS \$15406 \$I99805 \$15409 \$15405 \$15181 VDD DFFR_X1
X$7684 VSS \$15007 \$I100026 \$15151 \$15616 \$15181 VDD DFFR_X1
X$7688 \$15008 VSS VDD \$15451 CLKBUF_X1
X$7689 VSS \$15406 \$I100372 \$15197 \$14541 \$9850 VDD DFFR_X1
X$7691 \$14874 VSS VDD \$15369 CLKBUF_X1
X$7692 \$15368 VSS VDD \$15363 CLKBUF_X1
X$7693 \$15363 VSS VDD \$15366 CLKBUF_X1
X$7694 \$15366 VSS VDD \$15198 CLKBUF_X1
X$7695 \$15199 VSS VDD \$15362 CLKBUF_X1
X$7696 \$15362 VSS VDD \$15360 CLKBUF_X1
X$7698 \$15360 VSS VDD \$15200 CLKBUF_X1
X$7699 \$13678 VSS VDD \$14825 CLKBUF_X1
X$7701 \$14273 VSS VDD \$14622 CLKBUF_X1
X$7704 \$15332 VSS VDD \$15203 INV_X1
X$7705 VSS \$15324 \$15332 \$15326 \$14272 \$15204 VDD FA_X1
X$7706 VSS \$15294 \$15324 \$15594 \$15296 \$15309 VDD FA_X1
X$7710 \$15210 \$13571 VSS VDD \$15207 NAND2_X1
X$7715 \$13844 \$13033 VSS VDD \$15289 NOR2_X1
X$7718 \$14594 VSS VDD \$13571 INV_X4
X$7722 \$15370 VSS VDD \$15460 CLKBUF_X1
X$7723 \$15451 VSS VDD \$15009 CLKBUF_X1
X$7731 \$15411 \$15570 VDD VSS \$15322 XNOR2_X1
X$7732 \$15606 \$15570 \$15411 VSS \$14883 VDD AOI21_X1
X$7734 \$15326 VSS VDD \$15605 INV_X1
X$7739 \$13844 \$12651 VSS VDD \$15793 NOR2_X1
X$7740 \$15444 VSS VDD \$15719 INV_X1
X$7742 \$13515 \$13033 VSS VDD \$15444 NAND2_X1
X$7743 \$13515 \$12651 VSS VDD \$15576 NAND2_X1
X$7745 \$15209 VSS VDD \$15769 INV_X1
X$7750 \$15210 \$12651 VSS VDD \$15413 NAND2_X1
X$7753 VSS \$15434 \$15577 \$15586 \$15413 \$15587 VDD FA_X1
X$7755 \$14700 \$13033 VSS VDD \$15434 NAND2_X1
X$7757 \$15151 VSS VDD \$15213 INV_X1
X$7761 \$15151 \$13398 VSS VDD \$15216 NAND2_X1
X$7762 \$15216 VSS VDD \$15240 INV_X1
X$7763 \$15418 VSS VDD \$15244 INV_X1
X$7765 \$15240 \$15244 \$15218 VDD VSS \$15732 HA_X1
X$7769 VSS \$14280 \$I100393 \$14288 \$15237 \$9850 VDD DFFR_X1
X$7770 \$15220 VSS VDD \$15023 CLKBUF_X1
X$7773 \$15221 VSS VDD \$15222 CLKBUF_X1
X$7780 \$15213 \$14594 VSS VDD \$16172 NOR2_X1
X$7784 \$15190 \$13033 VSS VDD \$15418 NAND2_X1
X$7785 \$14143 \$15213 \$15418 VSS VDD \$15422 NOR3_X1
X$7787 \$15422 \$15218 \$15579 VDD VSS \$15744 HA_X1
X$7810 \$3151 VSS VDD \$3152 CLKBUF_X1
X$7812 \$2786 VSS VDD \$2998 CLKBUF_X1
X$7813 \$3311 VSS VDD \$3309 CLKBUF_X1
X$7814 \$2913 VSS VDD \$3311 CLKBUF_X1
X$7815 VSS \$3244 \$I100409 \$3321 \$3504 \$1304 VDD DFFR_X1
X$7818 \$3309 VSS VDD \$3796 CLKBUF_X1
X$7819 \$3308 VSS VDD \$3618 CLKBUF_X1
X$7820 \$3503 VSS VDD \$3314 CLKBUF_X1
X$7821 \$3199 VSS VDD \$3327 CLKBUF_X1
X$7822 VSS \$3244 \$I99812 \$3323 \$3314 \$1304 VDD DFFR_X1
X$7823 \$3321 VSS VDD \$3199 CLKBUF_X1
X$7824 \$3323 VSS VDD \$3657 CLKBUF_X1
X$7826 \$3319 VSS VDD \$3556 CLKBUF_X1
X$7828 \$3507 VSS VDD \$3668 CLKBUF_X1
X$7829 \$3327 VSS VDD \$3308 CLKBUF_X1
X$7830 \$2862 VSS VDD \$I94838 CLKBUF_X1
X$7831 \$3002 VSS VDD \$3153 CLKBUF_X1
X$7832 \$2931 VSS VDD \$3333 CLKBUF_X1
X$7833 \$3333 VSS VDD \$3154 CLKBUF_X1
X$7834 VSS \$2862 \$I100264 \$3343 \$3336 \$1304 VDD DFFR_X1
X$7835 \$3335 VSS VDD \$3334 CLKBUF_X1
X$7838 \$3331 VSS VDD \$3336 CLKBUF_X1
X$7839 \$2800 VSS VDD \$3331 CLKBUF_X1
X$7840 \$3334 VSS VDD \$3509 CLKBUF_X1
X$7841 \$3338 VSS VDD \$3335 CLKBUF_X1
X$7842 \$1692 VSS VDD \$2862 CLKBUF_X3
X$7843 \$3248 VSS VDD \$3564 CLKBUF_X1
X$7844 VSS \$2862 \$I99914 \$3514 \$3564 \$1304 VDD DFFR_X1
X$7845 \$3004 VSS VDD \$3155 CLKBUF_X1
X$7846 \$3155 VSS VDD \$3348 CLKBUF_X1
X$7847 \$3348 VSS VDD \$2864 CLKBUF_X1
X$7848 \$2735 VSS VDD \$3351 CLKBUF_X1
X$7849 \$3351 VSS VDD \$3076 CLKBUF_X1
X$7852 \$3353 VSS VDD \$3250 CLKBUF_X1
X$7853 \$3005 VSS VDD \$3353 CLKBUF_X1
X$7854 \$3250 VSS VDD \$2865 CLKBUF_X1
X$7855 \$2736 VSS VDD \$3354 CLKBUF_X1
X$7856 \$3354 VSS VDD \$3081 CLKBUF_X1
X$7858 \$3157 VSS VDD \$3252 CLKBUF_X1
X$7859 \$3360 VSS VDD \$3157 CLKBUF_X1
X$7860 \$3252 VSS VDD \$3356 CLKBUF_X1
X$7861 \$3159 VSS VDD \$3360 CLKBUF_X1
X$7862 \$3158 VSS VDD \$3159 CLKBUF_X1
X$7866 \$3346 VSS VDD \$3515 CLKBUF_X1
X$7867 \$3343 VSS VDD \$3338 CLKBUF_X1
X$7870 \$3355 VSS VDD \$3626 CLKBUF_X1
X$7872 \$3356 VSS VDD \$3251 CLKBUF_X1
X$7873 VSS \$3074 \$I99997 \$3574 \$3251 \$3006 VDD DFFR_X1
X$7875 \$3575 VSS VDD \$3694 CLKBUF_X1
X$7877 \$2134 \$2647 VDD VSS \$3516 XNOR2_X1
X$7879 \$2647 \$3369 VSS VDD \$2868 NAND2_X1
X$7884 \$3837 \$3255 \$3254 VDD \$3369 VSS OAI21_X1
X$7885 \$3256 \$3377 \$3373 VSS \$2134 VDD AOI21_X1
X$7886 \$3372 VSS VDD \$3377 INV_X1
X$7887 \$3379 \$3382 VSS VDD \$3372 NAND2_X1
X$7889 \$3386 \$3255 \$3254 VDD \$3256 VSS OAI21_X1
X$7891 \$3519 \$3518 \$3382 VDD VSS \$3387 HA_X1
X$7893 \$3257 \$2822 \$3379 VDD VSS \$3258 HA_X1
X$7895 VSS \$3391 \$3259 \$3260 \$3394 \$3009 VDD FA_X1
X$7897 \$3387 VSS VDD \$3386 INV_X1
X$7898 \$3258 VSS VDD \$3254 INV_X1
X$7900 VSS \$3390 \$3257 \$3518 \$3008 \$3584 VDD FA_X1
X$7902 \$3259 VSS VDD \$3584 INV_X1
X$7904 \$3388 VSS VDD \$3855 INV_X1
X$7905 \$3392 \$3587 \$3388 VDD VSS \$3390 HA_X1
X$7906 \$3260 VSS VDD \$3392 INV_X1
X$7909 \$3397 VSS VDD \$3394 INV_X1
X$7911 \$3400 \$2744 \$3161 VDD VSS \$3397 HA_X1
X$7915 \$3243 \$3520 \$3585 VDD VSS \$3521 HA_X1
X$7917 \$2745 \$2410 \$3591 VDD VSS \$3243 HA_X1
X$7918 \$2408 VSS VDD \$3162 CLKBUF_X1
X$7927 \$3238 VSS VDD \$3163 CLKBUF_X1
X$7928 \$3237 \$3163 VSS VDD \$1161 NAND2_X1
X$7930 \$3262 \$3164 VSS VDD \$3237 OR2_X1
X$7931 \$20 \$3164 \$3262 VSS \$3238 VDD AOI21_X1
X$7932 \$3424 VSS VDD \$3100 CLKBUF_X1
X$7934 \$1160 VSS VDD \$3523 CLKBUF_X1
X$7935 \$3415 \$3165 \$3596 VSS \$3262 VDD AOI21_X1
X$7936 \$3418 \$2587 VSS VDD \$3596 NAND2_X1
X$7937 \$3418 \$3525 VSS VDD \$3012 NAND2_X1
X$7939 \$3526 VSS VDD \$2587 INV_X1
X$7940 \$3121 VSS VDD \$3424 CLKBUF_X1
X$7946 \$1993 VSS VDD \$3265 CLKBUF_X1
X$7949 \$3232 VSS VDD \$3233 CLKBUF_X1
X$7952 \$2425 VSS VDD \$4275 CLKBUF_X1
X$7954 VSS \$2347 \$I100040 \$3529 \$3429 \$45 VDD DFFR_X1
X$7955 \$3438 VSS VDD \$3232 CLKBUF_X1
X$7956 \$2855 VSS VDD \$2981 CLKBUF_X1
X$7958 \$1876 VSS VDD \$3230 CLKBUF_X1
X$7959 \$3441 VSS VDD \$3438 CLKBUF_X1
X$7960 \$3268 VSS VDD \$3168 CLKBUF_X1
X$7962 \$3449 VSS VDD \$3226 CLKBUF_X1
X$7963 \$3444 VSS VDD \$3634 CLKBUF_X1
X$7965 VSS \$2347 \$I99946 \$3774 \$3269 \$45 VDD DFFR_X1
X$7967 \$2347 VSS VDD \$I101709 INV_X2
X$7968 \$3450 VSS VDD \$3449 CLKBUF_X1
X$7969 \$3169 VSS VDD \$3450 CLKBUF_X1
X$7971 \$191 VSS VDD \$2347 CLKBUF_X3
X$7973 \$3272 VSS VDD \$3169 CLKBUF_X1
X$7975 \$3453 VSS VDD \$3272 CLKBUF_X1
X$7978 \$3458 \$2349 \$4282 VDD VSS \$3460 HA_X1
X$7979 \$3467 VSS VDD \$3131 CLKBUF_X1
X$7982 VSS \$3470 \$3223 \$3221 \$3466 \$3275 VDD FA_X1
X$7987 \$3460 VSS VDD \$4519 INV_X1
X$7990 \$3609 VSS VDD \$3138 CLKBUF_X1
X$7991 VSS \$2994 \$3742 \$3469 \$3019 \$3615 VDD FA_X1
X$7992 \$3469 VSS VDD \$3275 INV_X1
X$7996 xin[5] VSS VDD \$19509 BUF_X1
X$7999 \$19436 VSS VDD \$19530 CLKBUF_X1
X$8000 \$19530 VSS VDD \$19531 CLKBUF_X1
X$8005 \$19510 VSS VDD \$19535 CLKBUF_X1
X$8006 \$19535 VSS VDD \$19610 CLKBUF_X1
X$8007 VSS \$19381 \$I100354 \$19537 \$17542 \$15672 VDD DFFR_X1
X$8018 \$19610 VSS VDD \$19609 CLKBUF_X1
X$8019 \$19439 VSS VDD \$19643 CLKBUF_X1
X$8020 \$19381 VSS VDD \$I91480 CLKBUF_X1
X$8021 \$19643 VSS VDD \$19669 CLKBUF_X1
X$8022 VSS \$19381 \$I100107 \$19681 \$19669 \$15672 VDD DFFR_X1
X$8023 \$19538 VSS VDD \$19540 CLKBUF_X1
X$8024 \$19537 VSS VDD \$19538 CLKBUF_X1
X$8025 \$19511 VSS VDD \$19440 CLKBUF_X1
X$8026 \$19541 VSS VDD \$19587 CLKBUF_X1
X$8027 \$19540 VSS VDD \$19541 CLKBUF_X1
X$8028 \$12618 VSS VDD \$19151 CLKBUF_X1
X$8029 VSS \$19381 \$I100238 \$19623 \$19588 \$15672 VDD DFFR_X1
X$8033 \$19587 VSS VDD \$19675 CLKBUF_X1
X$8034 \$19675 VSS VDD \$19588 CLKBUF_X1
X$8037 \$19623 VSS VDD \$19677 CLKBUF_X1
X$8038 \$19677 VSS VDD \$19644 INV_X1
X$8041 \$19624 \$19647 VDD VSS \$19514 XNOR2_X1
X$8042 \$19514 VSS VDD \$19589 CLKBUF_X1
X$8046 \$19556 \$19553 \$19630 VDD VSS \$19557 HA_X1
X$8047 \$19479 VSS VDD \$19635 CLKBUF_X1
X$8050 \$19589 VSS VDD \$19683 INV_X1
X$8051 \$19625 \$19683 VDD VSS \$19628 XNOR2_X1
X$8052 \$19681 VSS VDD \$19692 CLKBUF_X1
X$8055 \$19630 VSS VDD \$19590 INV_X1
X$8057 \$19628 \$19688 VDD VSS \$19703 XNOR2_X1
X$8058 \$19590 \$19388 \$19591 VDD \$19688 VSS OAI21_X1
X$8060 \$19557 VSS VDD \$19591 INV_X1
X$8065 \$19388 \$19590 VDD VSS \$19593 XNOR2_X1
X$8066 \$19593 VSS VDD \$19695 INV_X1
X$8069 \$19692 \$19695 \$19693 VDD VSS \$19639 HA_X1
X$8072 \$19515 VSS VDD \$19560 INV_X1
X$8074 \$19635 \$19560 \$19516 VDD VSS \$19517 HA_X1
X$8075 \$19517 \$19516 \$19641 VSS \$19594 VDD AOI21_X1
X$8077 \$19516 VSS VDD \$19565 INV_X1
X$8078 \$19516 VSS VDD \$19570 CLKBUF_X1
X$8079 \$19565 \$19390 \$19562 VDD \$19595 VSS OAI21_X1
X$8082 \$19445 VSS VDD \$19641 INV_X1
X$8084 \$19445 \$19570 VDD VSS \$19518 XNOR2_X1
X$8085 \$19518 VSS VDD \$19572 CLKBUF_X1
X$8086 VSS \$19295 \$I100262 \$19596 \$19572 \$15541 VDD DFFR_X1
X$8090 \$19693 VSS VDD \$19698 CLKBUF_X1
X$8093 \$19639 VSS VDD \$19699 INV_X1
X$8095 \$19698 VSS VDD \$19696 INV_X1
X$8096 \$19696 \$19594 \$19699 VDD \$19624 VSS OAI21_X1
X$8099 \$19595 \$19648 VDD VSS \$19766 XNOR2_X1
X$8103 \$19596 VSS VDD \$19711 CLKBUF_X1
X$8104 \$19500 VSS VDD \$19498 CLKBUF_X1
X$8105 \$19446 VSS VDD \$19575 CLKBUF_X1
X$8106 \$19578 VSS VDD \$19394 CLKBUF_X1
X$8110 \$19448 VSS VDD \$19520 CLKBUF_X1
X$8112 \$19521 VSS VDD \$19583 INV_X1
X$8113 \$19585 \$19521 \$19582 VSS \$19598 VDD AOI21_X1
X$8114 \$19583 \$19198 \$19631 VDD \$19581 VSS OAI21_X1
X$8115 \$19585 VSS VDD \$19631 INV_X1
X$8116 \$17010 VSS VDD \$19274 CLKBUF_X1
X$8118 \$19581 \$19600 VDD VSS \$19051 XNOR2_X1
X$8122 \$19571 \$19450 VSS VDD \$19601 NAND2_X1
X$8125 \$19451 VSS VDD \$19571 INV_X1
X$8128 \$19711 VSS VDD \$19710 CLKBUF_X1
X$8130 \$19710 VSS VDD \$19713 CLKBUF_X1
X$8131 \$19713 VSS VDD \$19649 CLKBUF_X1
X$8134 \$19597 VSS VDD \$19715 CLKBUF_X1
X$8135 VSS \$19651 \$I100110 \$19653 \$19715 \$15541 VDD DFFR_X1
X$8138 \$19721 VSS VDD \$19637 CLKBUF_X1
X$8139 \$19521 VSS VDD \$19632 CLKBUF_X1
X$8140 \$19637 \$19724 \$19521 VDD VSS \$19585 HA_X1
X$8141 \$19726 VSS VDD \$19724 INV_X1
X$8142 \$19654 VSS VDD \$19600 CLKBUF_X1
X$8144 \$19601 \$19655 VDD VSS \$19726 XNOR2_X1
X$8146 \$19602 VSS VDD \$19656 INV_X1
X$8148 VSS \$19414 \$19602 \$19559 \$19618 \$19492 VDD FA_X1
X$8149 \$19559 VSS VDD \$19566 INV_X1
X$8153 \$19660 VSS VDD \$19546 INV_X1
X$8156 \$18628 \$18701 VSS VDD \$19821 OR2_X1
X$8157 \$19528 VSS VDD \$19615 INV_X1
X$8163 VSS \$19550 \$19657 \$19618 \$19614 \$19658 VDD FA_X1
X$8166 \$18804 \$17010 VDD VSS \$19746 AND2_X1
X$8167 \$19659 VSS VDD \$19709 INV_X1
X$8168 \$18052 \$18628 VSS VDD \$19659 NAND2_X1
X$8170 VSS \$19617 \$19661 \$19684 \$19454 \$19686 VDD FA_X1
X$8172 VSS \$19523 \$19944 \$19614 \$19615 \$19684 VDD FA_X1
X$8175 \$19607 VSS VDD \$19525 INV_X1
X$8176 VSS \$19458 \$19612 \$19528 \$19524 \$19525 VDD FA_X1
X$8195 \$18624 \$18628 VSS VDD \$19756 NAND2_X1
X$8198 \$18260 \$18628 VSS VDD \$19607 NAND2_X1
X$8249 \$9637 VSS VDD \$9634 CLKBUF_X1
X$8259 VSS \$9560 \$I100115 \$10021 \$9634 \$8875 VDD DFFR_X1
X$8260 \$9329 VSS VDD \$9637 CLKBUF_X1
X$8261 \$9641 VSS VDD \$9647 CLKBUF_X1
X$8262 \$9409 VSS VDD \$9406 CLKBUF_X1
X$8263 VSS \$9560 \$I100404 \$9561 \$9330 \$8875 VDD DFFR_X1
X$8268 \$9648 VSS VDD \$9095 CLKBUF_X1
X$8269 \$9804 VSS VDD \$9330 CLKBUF_X1
X$8270 \$9860 VSS VDD \$9804 CLKBUF_X1
X$8271 \$10151 VSS VDD \$10031 CLKBUF_X1
X$8273 \$9862 VSS VDD \$10034 CLKBUF_X1
X$8274 \$9561 VSS VDD \$9649 CLKBUF_X1
X$8275 \$9651 VSS VDD \$9098 CLKBUF_X1
X$8276 \$9418 VSS VDD \$9332 CLKBUF_X1
X$8277 \$9649 VSS VDD \$9650 CLKBUF_X1
X$8278 \$9647 VSS VDD \$9648 CLKBUF_X1
X$8280 \$8331 \$9658 \$9562 VDD VSS \$9872 HA_X1
X$8281 \$10536 \$9564 \$9333 VSS \$9665 VDD AOI21_X1
X$8283 \$9672 \$9103 \$9665 VDD \$9670 VSS OAI21_X1
X$8284 \$8974 VSS VDD \$9192 CLKBUF_X1
X$8285 \$9101 \$9564 VSS VDD \$9672 NAND2_X1
X$8289 VSS \$7564 \$I100245 \$9883 \$9335 \$8875 VDD DFFR_X1
X$8291 \$9650 VSS VDD \$9641 CLKBUF_X1
X$8293 \$9805 VSS VDD \$9662 INV_X1
X$8294 \$9805 \$9192 VSS VDD \$9807 NAND2_X1
X$8295 \$9562 VSS VDD \$9805 CLKBUF_X1
X$8296 \$9807 \$8603 \$9565 VDD \$10038 VSS OAI21_X1
X$8297 \$8878 \$9662 \$9563 VDD \$9809 VSS OAI21_X1
X$8298 \$9872 VSS VDD \$9563 INV_X1
X$8299 \$9809 VSS VDD \$9565 INV_X1
X$8302 \$8603 \$9192 VDD VSS \$9810 XNOR2_X1
X$8306 \$9883 \$7826 VSS VDD \$10050 NAND2_X1
X$8307 \$9684 VSS VDD \$9569 CLKBUF_X1
X$8309 \$9439 VSS VDD \$9337 CLKBUF_X1
X$8310 VSS \$7564 \$I100246 \$9571 \$9337 \$8875 VDD DFFR_X1
X$8311 \$7826 \$9571 VDD VSS \$8889 AND2_X1
X$8318 \$10164 VSS VDD \$8887 CLKBUF_X1
X$8319 \$10052 \$9883 \$9106 \$9571 VSS VDD \$9689 NOR4_X1
X$8323 VSS \$9695 \$10054 \$9811 \$9967 \$9895 VDD FA_X1
X$8324 VSS \$9696 \$9895 \$9694 \$9693 \$9338 VDD FA_X1
X$8326 \$9572 \$9107 VDD VSS \$9812 XNOR2_X1
X$8330 \$8532 \$7785 VSS VDD \$9972 NAND2_X1
X$8331 \$8350 \$8629 VSS VDD \$9342 NAND2_X1
X$8332 \$9342 VSS VDD \$9711 INV_X1
X$8333 \$8894 VSS VDD \$9465 CLKBUF_X1
X$8337 \$9715 VSS VDD \$9470 CLKBUF_X1
X$8340 VSS \$9572 \$10257 \$9695 \$9693 \$9901 VDD FA_X1
X$8341 \$9900 VSS VDD \$9813 INV_X1
X$8345 \$9908 VSS VDD \$9815 INV_X1
X$8346 \$7785 \$9110 VSS VDD \$9814 NOR2_X1
X$8347 \$8350 \$7339 VSS VDD \$9908 NAND2_X1
X$8349 \$7339 \$8532 VSS VDD \$10072 NAND2_X1
X$8350 \$9915 VSS VDD \$9817 INV_X1
X$8351 \$8350 \$7785 VSS VDD \$9915 NAND2_X1
X$8352 \$8629 \$9110 VSS VDD \$10276 NOR2_X1
X$8353 VSS \$9711 \$9819 \$9821 \$9709 \$9973 VDD FA_X1
X$8355 \$6756 \$9110 VSS VDD \$9709 NOR2_X1
X$8358 \$8350 \$6756 VSS VDD \$9577 NAND2_X1
X$8359 \$9577 VSS VDD \$9822 INV_X1
X$8360 \$8532 \$8629 VSS VDD \$9578 NAND2_X1
X$8361 \$9578 VSS VDD \$9974 INV_X1
X$8367 \$7846 \$9110 VSS VDD \$9825 NOR2_X1
X$8371 \$9580 VSS VDD \$9727 CLKBUF_X1
X$8373 \$8269 \$9110 VSS VDD \$10086 NOR2_X1
X$8374 \$9826 VSS VDD \$9977 INV_X1
X$8375 \$8350 \$7846 VSS VDD \$9826 NAND2_X1
X$8376 \$8629 \$9122 VSS VDD \$9343 NAND2_X1
X$8377 \$9343 VSS VDD \$9583 INV_X1
X$8378 \$9473 VSS VDD \$9728 CLKBUF_X1
X$8379 \$7785 \$8627 VSS VDD \$9585 NAND2_X1
X$8380 \$9585 VSS VDD \$9586 INV_X1
X$8381 \$9728 VSS VDD \$9733 CLKBUF_X1
X$8383 \$9733 VSS VDD \$9478 CLKBUF_X1
X$8387 VSS \$9586 \$10284 \$10092 \$9583 \$9827 VDD FA_X1
X$8388 \$9727 VSS VDD \$9954 CLKBUF_X1
X$8389 \$9828 VSS VDD \$9827 INV_X1
X$8390 \$7339 \$9580 VSS VDD \$9828 NAND2_X1
X$8391 \$8532 \$7846 VSS VDD \$9587 NAND2_X1
X$8392 \$9587 VSS VDD \$9831 INV_X1
X$8395 \$9737 VSS VDD \$9498 CLKBUF_X1
X$8396 \$9481 VSS VDD \$9737 CLKBUF_X1
X$8397 \$8901 VSS VDD \$9589 CLKBUF_X1
X$8398 \$9739 VSS VDD \$9590 CLKBUF_X1
X$8399 \$8355 VSS VDD \$9750 CLKBUF_X1
X$8400 VSS \$9119 \$I100175 \$9592 \$9497 \$6364 VDD DFFR_X1
X$8402 \$9344 VSS VDD \$9594 CLKBUF_X1
X$8403 \$9752 VSS VDD \$9344 CLKBUF_X1
X$8404 \$9594 VSS VDD \$9505 CLKBUF_X1
X$8405 \$10130 VSS VDD \$9595 CLKBUF_X1
X$8406 VSS \$9307 \$I100513 \$9126 \$9348 \$6364 VDD DFFR_X1
X$8408 VSS \$9307 \$I100194 \$9773 \$9600 \$6763 VDD DFFR_X1
X$8409 \$9599 VSS VDD \$9832 CLKBUF_X1
X$8410 \$9354 VSS VDD \$9353 CLKBUF_X1
X$8413 \$9955 VSS VDD \$10296 CLKBUF_X1
X$8414 \$8625 VSS VDD \$10295 CLKBUF_X1
X$8415 VSS \$9119 \$I99856 \$10102 \$9589 \$6364 VDD DFFR_X1
X$8416 VSS \$9119 \$I99865 \$10120 \$9982 \$6364 VDD DFFR_X1
X$8417 VSS \$9307 \$I99961 \$10132 \$9960 \$6364 VDD DFFR_X1
X$8418 \$9943 VSS VDD \$9307 CLKBUF_X3
X$8419 \$10134 VSS VDD \$10142 CLKBUF_X1
X$8421 \$9350 VSS VDD \$9599 CLKBUF_X1
X$8422 \$9351 VSS VDD \$9598 CLKBUF_X1
X$8423 \$9307 VSS VDD \$I91983 CLKBUF_X1
X$8424 \$9598 VSS VDD \$9600 CLKBUF_X1
X$8427 \$9832 VSS VDD \$9833 CLKBUF_X1
X$8428 \$8907 VSS VDD \$9531 CLKBUF_X1
X$8429 \$9355 VSS VDD \$9542 CLKBUF_X1
X$8430 \$8635 VSS VDD \$I93621 CLKBUF_X1
X$8431 \$5666 VSS VDD \$8635 CLKBUF_X3
X$8432 \$9131 VSS VDD \$8136 CLKBUF_X1
X$8433 \$9775 VSS VDD \$9558 CLKBUF_X1
X$8434 \$9358 VSS VDD \$9778 CLKBUF_X1
X$8436 \$9359 VSS VDD \$9552 CLKBUF_X1
X$8437 \$9360 VSS VDD \$9602 CLKBUF_X1
X$8438 \$10350 VSS VDD \$9603 CLKBUF_X1
X$8439 \$9932 VSS VDD \$9784 CLKBUF_X1
X$8440 \$9558 VSS VDD \$9782 CLKBUF_X1
X$8443 \$9773 VSS VDD \$9775 CLKBUF_X1
X$8444 \$9833 VSS VDD \$9938 CLKBUF_X1
X$8445 \$8855 VSS VDD \$10513 CLKBUF_X1
X$8446 \$10343 VSS VDD \$9948 CLKBUF_X1
X$8447 \$9948 VSS VDD \$9932 CLKBUF_X1
X$8448 \$9944 VSS VDD \$10143 CLKBUF_X1
X$8449 \$9940 VSS VDD \$9944 CLKBUF_X1
X$8450 VSS \$8635 \$I99879 \$9931 \$9938 \$6763 VDD DFFR_X1
X$8471 xin[7] VSS VDD \$17849 BUF_X1
X$8480 VSS \$17372 \$I100429 \$18112 \$18390 \$12319 VDD DFFR_X1
X$8481 VSS \$17598 \$I100220 \$17929 \$17928 \$12319 VDD DFFR_X1
X$8482 \$17110 VSS VDD \$17598 CLKBUF_X3
X$8483 \$17976 VSS VDD \$17810 CLKBUF_X1
X$8484 \$17930 VSS VDD \$17985 CLKBUF_X1
X$8485 \$17985 VSS VDD \$17543 CLKBUF_X1
X$8486 \$17811 VSS VDD \$17645 CLKBUF_X1
X$8487 \$17813 VSS VDD \$17812 CLKBUF_X1
X$8488 \$17875 VSS VDD \$17868 CLKBUF_X1
X$8493 \$18112 VSS VDD \$17926 CLKBUF_X1
X$8494 \$17926 VSS VDD \$18227 CLKBUF_X1
X$8495 \$18183 VSS VDD \$18067 CLKBUF_X1
X$8496 \$18116 VSS VDD \$17928 CLKBUF_X1
X$8497 \$18067 VSS VDD \$18116 CLKBUF_X1
X$8498 \$18228 VSS VDD \$18118 CLKBUF_X1
X$8499 \$17861 VSS VDD \$17971 CLKBUF_X1
X$8500 VSS \$17598 \$I100070 \$18068 \$18184 \$15672 VDD DFFR_X1
X$8501 VSS \$17598 \$I100033 \$17939 \$18069 \$15672 VDD DFFR_X1
X$8502 \$17931 VSS VDD \$18070 CLKBUF_X1
X$8503 \$17646 VSS VDD \$17931 CLKBUF_X1
X$8504 \$17816 VSS VDD \$17993 CLKBUF_X1
X$8505 \$17932 VSS VDD \$17816 CLKBUF_X1
X$8507 \$18070 VSS VDD \$17932 CLKBUF_X1
X$8509 \$17994 VSS VDD \$17818 CLKBUF_X1
X$8510 \$17993 VSS VDD \$17994 CLKBUF_X1
X$8513 \$17819 VSS VDD \$17996 CLKBUF_X1
X$8514 \$17996 VSS VDD \$17821 CLKBUF_X1
X$8515 \$17998 VSS VDD \$17733 CLKBUF_X1
X$8516 \$17997 VSS VDD \$17649 CLKBUF_X1
X$8517 \$17821 VSS VDD \$17998 CLKBUF_X1
X$8521 \$18004 \$18005 \$18002 VDD VSS \$18344 HA_X1
X$8524 \$17820 \$13181 VSS VDD \$18018 NOR2_X1
X$8527 \$17817 \$13178 VSS VDD \$17937 NAND2_X1
X$8528 \$17937 VSS VDD \$17938 INV_X1
X$8530 \$17939 \$13178 VSS VDD \$17940 NAND2_X1
X$8532 \$17940 VSS VDD \$18025 INV_X1
X$8534 \$18025 \$18030 \$18024 VDD VSS \$17941 HA_X1
X$8536 \$17824 VSS VDD \$18030 INV_X1
X$8538 \$17817 \$13181 VSS VDD \$17824 NAND2_X1
X$8541 \$17760 \$17654 \$17942 VDD VSS \$18036 HA_X1
X$8545 \$18131 VSS VDD \$18072 INV_X1
X$8549 \$17817 VSS VDD \$18134 CLKBUF_X1
X$8551 \$17888 VSS VDD \$18142 CLKBUF_X1
X$8555 \$17820 \$13041 VSS VDD \$18251 NOR2_X1
X$8557 \$18142 VSS VDD \$18148 CLKBUF_X1
X$8560 \$17817 \$13041 VSS VDD \$17933 NAND2_X1
X$8561 \$17933 VSS VDD \$18261 INV_X1
X$8564 \$17820 \$13178 VSS VDD \$18145 NOR2_X1
X$8567 \$17939 \$13041 VSS VDD \$17935 NAND2_X1
X$8568 \$17935 VSS VDD \$18153 INV_X1
X$8569 VSS \$17938 \$18082 \$18157 \$18018 \$18153 VDD FA_X1
X$8570 VSS \$17941 \$18480 \$18026 \$18157 \$18158 VDD FA_X1
X$8576 \$18083 \$17942 \$16885 VSS VDD \$18084 NAND3_X1
X$8577 \$18036 \$18083 VSS VDD \$18165 NAND2_X1
X$8579 \$17365 VSS VDD \$I101757 INV_X4
X$8581 \$17365 VSS VDD \$16886 CLKBUF_X3
X$8582 VSS \$16886 \$I100228 \$18175 \$18042 \$15541 VDD DFFR_X1
X$8583 \$17829 VSS VDD \$17830 INV_X1
X$8584 \$17946 VSS VDD \$17924 CLKBUF_X1
X$8585 \$17924 \$17831 \$17947 VDD VSS \$18089 HA_X1
X$8589 \$16886 VSS VDD \$I92640 CLKBUF_X1
X$8591 \$18171 VSS VDD \$18042 CLKBUF_X1
X$8592 \$18173 VSS VDD \$18086 CLKBUF_X1
X$8593 \$17828 VSS VDD \$18172 CLKBUF_X1
X$8594 \$18172 VSS VDD \$18173 CLKBUF_X1
X$8595 \$18086 VSS VDD \$18171 CLKBUF_X1
X$8598 \$18175 VSS VDD \$17946 CLKBUF_X1
X$8599 \$17830 \$18087 VDD VSS \$18045 XNOR2_X1
X$8600 \$18088 \$17947 \$17077 VSS VDD \$18090 NAND3_X1
X$8602 \$17915 VSS VDD \$17831 INV_X1
X$8606 \$18414 VSS VDD \$15546 CLKBUF_X1
X$8608 \$18054 VSS VDD \$17920 CLKBUF_X1
X$8610 \$17658 VSS VDD \$18056 CLKBUF_X1
X$8611 \$18057 VSS VDD \$17916 CLKBUF_X1
X$8612 \$17949 VSS VDD \$17917 CLKBUF_X1
X$8613 \$18056 VSS VDD \$18057 CLKBUF_X1
X$8620 \$17789 \$18180 VDD VSS \$17915 XNOR2_X1
X$8622 \$17950 VSS VDD \$18066 CLKBUF_X1
X$8623 \$18066 VSS VDD \$17907 CLKBUF_X1
X$8624 VSS \$17901 \$17951 \$17908 \$18382 \$18065 VDD FA_X1
X$8625 VSS \$17952 \$18065 \$17895 \$18061 \$18043 VDD FA_X1
X$8626 \$17892 VSS VDD \$18061 INV_X1
X$8628 VSS \$16489 \$18048 \$18052 \$18059 \$16907 VDD DFFR_X1
X$8630 \$18041 \$16486 VSS VDD \$17889 NAND2_X1
X$8631 \$18052 VSS VDD \$17838 CLKBUF_X1
X$8632 \$18048 VSS VDD \$18041 INV_X1
X$8633 \$16335 \$17559 VSS VDD \$17953 NAND2_X1
X$8634 \$17953 VSS VDD \$18040 INV_X1
X$8636 \$18038 VSS VDD \$18037 INV_X1
X$8637 \$18037 \$18040 \$18035 VDD VSS \$18043 HA_X1
X$8639 \$17954 VSS VDD \$17955 CLKBUF_X1
X$8641 \$17669 \$18022 \$17671 VDD \$18017 VSS OAI21_X1
X$8644 \$18179 \$18180 \$17789 VSS \$18064 VDD AOI21_X1
X$8645 \$17951 \$18266 \$18180 VDD VSS \$18179 HA_X1
X$8649 \$18091 VSS VDD \$17796 CLKBUF_X1
X$8650 \$17904 VSS VDD \$18177 CLKBUF_X1
X$8652 \$18177 VSS VDD \$18059 CLKBUF_X1
X$8656 \$16672 \$18093 VSS VDD \$18038 NAND2_X1
X$8658 \$16898 \$18093 \$17954 VDD VSS \$18096 HA_X1
X$8659 \$18096 \$17955 \$18017 VSS \$18095 VDD AOI21_X1
X$8661 \$18096 \$17954 \$17562 VSS \$18154 VDD AOI21_X1
X$8662 \$17955 VSS VDD \$18097 INV_X1
X$8664 \$17671 \$18097 \$18101 VDD \$18100 VSS OAI21_X1
X$8665 \$18096 VSS VDD \$18101 INV_X1
X$8666 \$18014 VSS VDD \$17883 CLKBUF_X1
X$8672 \$18097 \$17669 \$18434 VSS VDD \$18137 NOR3_X1
X$8675 \$17563 VSS VDD \$18301 INV_X1
X$8677 \$17840 VSS VDD \$18139 INV_X1
X$8680 \$17601 \$18137 VSS VDD \$18012 NAND2_X1
X$8681 \$18637 \$18137 \$17565 VSS \$18011 VDD AOI21_X1
X$8682 \$18012 \$17407 \$18011 VDD \$18102 VSS OAI21_X1
X$8684 \$17674 VSS VDD \$17956 CLKBUF_X1
X$8687 \$17570 VSS VDD \$18006 CLKBUF_X1
X$8688 \$17463 \$18006 VSS VDD \$17957 XOR2_X1
X$8689 VSS \$17275 \$I100335 \$17960 \$17958 \$16907 VDD DFFR_X1
X$8690 VSS \$17275 \$I100419 \$17679 \$17986 \$16907 VDD DFFR_X1
X$8691 \$17970 \$18225 VDD VSS \$17984 XNOR2_X1
X$8693 \$17846 \$18223 \$17844 \$17859 \$17845 VDD VSS \$17463 OAI221_X1
X$8694 \$17972 VSS VDD \$17846 INV_X1
X$8696 \$17680 VSS VDD \$17845 CLKBUF_X1
X$8697 \$17968 \$17846 \$17856 VSS VDD \$17970 NAND3_X1
X$8698 \$17681 VSS VDD \$17572 CLKBUF_X1
X$8699 \$17969 VSS VDD \$17853 CLKBUF_X1
X$8715 \$18009 VSS VDD \$18103 CLKBUF_X1
X$8716 VSS \$16572 \$I99919 \$18303 \$18103 \$16907 VDD DFFR_X1
X$8717 \$17957 VSS VDD \$17958 CLKBUF_X1
X$8723 \$17960 VSS VDD \$18104 INV_X1
X$8726 \$17844 \$17962 VSS VDD \$17677 NAND2_X1
X$8727 \$17984 VSS VDD \$17986 CLKBUF_X1
X$8729 \$17724 VSS VDD \$18106 CLKBUF_X1
X$8730 \$17724 \$17970 VSS VDD \$17962 NAND2_X1
X$8731 \$17277 \$18110 \$17694 VDD VSS \$17972 HA_X1
X$8732 \$17845 \$18307 VDD VSS \$18218 XNOR2_X1
X$8755 VSS \$15449 \$I100045 \$15670 \$15890 \$15672 VDD DFFR_X1
X$8760 VSS \$15449 \$I100501 \$12827 \$15739 \$8875 VDD DFFR_X1
X$8762 \$15891 VSS VDD \$15671 CLKBUF_X1
X$8763 \$15972 VSS VDD \$15739 CLKBUF_X1
X$8764 \$15671 VSS VDD \$15972 CLKBUF_X1
X$8765 \$15522 VSS VDD \$15984 INV_X1
X$8766 \$15582 VSS VDD \$16181 INV_X1
X$8768 \$13536 VSS VDD \$15978 INV_X1
X$8769 VSS \$15673 \$15983 \$15892 \$14842 \$15984 VDD FA_X1
X$8770 \$15672 VSS VDD \$8875 BUF_X2
X$8773 \$12827 VSS VDD \$15754 CLKBUF_X1
X$8776 VSS \$15428 \$15986 \$15592 \$15045 \$15525 VDD FA_X1
X$8777 VSS \$15526 \$15675 \$15759 \$14847 \$15592 VDD FA_X1
X$8782 \$15754 VSS VDD \$15988 CLKBUF_X1
X$8783 VSS \$15675 \$16187 \$15991 \$15674 \$15986 VDD FA_X1
X$8784 \$15988 VSS VDD \$15992 CLKBUF_X1
X$8787 \$15992 VSS VDD \$15997 CLKBUF_X1
X$8789 VSS \$15677 \$15893 \$15995 \$15759 \$15762 VDD FA_X1
X$8790 \$15162 VSS VDD \$15762 INV_X1
X$8792 \$15449 VSS VDD \$I101713 INV_X2
X$8793 \$13150 VSS VDD \$15449 CLKBUF_X3
X$8794 \$15527 VSS VDD \$15677 INV_X1
X$8796 VSS \$15449 \$I100281 \$15679 \$15764 \$12319 VDD DFFR_X1
X$8797 \$15608 VSS VDD \$15681 CLKBUF_X1
X$8798 \$15776 VSS VDD \$15608 CLKBUF_X1
X$8799 \$15681 VSS VDD \$15531 CLKBUF_X1
X$8800 \$2886 VSS VDD \$13150 CLKBUF_X3
X$8801 \$15768 VSS VDD \$16007 CLKBUF_X1
X$8803 \$15780 VSS VDD \$15781 CLKBUF_X1
X$8804 \$15781 VSS VDD \$15683 CLKBUF_X1
X$8805 \$15166 VSS VDD \$15784 CLKBUF_X1
X$8806 \$15784 VSS VDD \$15533 CLKBUF_X1
X$8807 \$15683 VSS VDD \$15165 CLKBUF_X1
X$8810 \$15622 VSS VDD \$15786 CLKBUF_X1
X$8811 \$15786 VSS VDD \$15684 CLKBUF_X1
X$8812 \$15170 VSS VDD \$15785 CLKBUF_X1
X$8813 \$15785 VSS VDD \$15534 CLKBUF_X1
X$8814 \$15684 VSS VDD \$15169 CLKBUF_X1
X$8818 \$15995 VSS VDD \$15998 INV_X1
X$8821 \$15997 VSS VDD \$15764 CLKBUF_X1
X$8824 \$16000 VSS VDD \$15896 INV_X1
X$8827 \$15529 \$15678 \$15164 VSS \$15899 VDD AOI21_X1
X$8829 \$15679 VSS VDD \$15768 CLKBUF_X1
X$8830 \$15164 \$15678 VSS VDD \$17053 XOR2_X1
X$8831 \$16007 VSS VDD \$15776 CLKBUF_X1
X$8835 \$15458 VSS VDD \$15794 CLKBUF_X1
X$8841 \$15388 \$13178 VSS VDD \$15688 NAND2_X1
X$8842 \$15688 VSS VDD \$16019 INV_X1
X$8843 \$15794 VSS VDD \$15798 CLKBUF_X1
X$8846 \$15909 \$16019 \$15690 VDD VSS \$16217 HA_X1
X$8848 \$15385 \$13098 VSS VDD \$15800 NAND2_X1
X$8849 \$15689 \$16023 \$15799 VDD VSS \$16025 HA_X1
X$8851 \$15800 VSS VDD \$15689 INV_X1
X$8854 \$15798 VSS VDD \$16022 CLKBUF_X1
X$8855 \$16022 VSS VDD \$16036 CLKBUF_X1
X$8856 \$16029 \$15910 \$15807 VDD VSS \$16032 HA_X1
X$8857 \$15458 \$13178 VSS VDD \$15804 NAND2_X1
X$8860 \$16032 VSS VDD \$15911 INV_X1
X$8863 \$15804 VSS VDD \$15537 INV_X1
X$8864 \$15690 \$15912 \$15175 VDD VSS \$15809 HA_X1
X$8865 \$15538 \$15799 \$15912 VDD VSS \$15815 HA_X1
X$8871 VSS \$15809 \$16037 \$15691 \$15807 \$15815 VDD FA_X1
X$8872 \$16228 VSS VDD \$15477 CLKBUF_X1
X$8877 VSS \$14990 \$I100421 \$15824 \$16328 \$15181 VDD DFFR_X1
X$8879 \$16230 \$15691 \$15540 VSS VDD \$16122 NAND3_X1
X$8885 \$15824 VSS VDD \$15829 CLKBUF_X1
X$8886 \$15654 VSS VDD \$15693 CLKBUF_X1
X$8887 \$15913 VSS VDD \$15826 CLKBUF_X1
X$8888 \$15656 VSS VDD \$15655 CLKBUF_X1
X$8889 \$12743 VSS VDD \$14990 CLKBUF_X3
X$8891 \$15542 VSS VDD \$15180 CLKBUF_X1
X$8892 \$15543 VSS VDD \$14991 CLKBUF_X1
X$8893 \$15828 VSS VDD \$15544 CLKBUF_X1
X$8894 \$15544 VSS VDD \$15665 CLKBUF_X1
X$8895 \$15182 VSS VDD \$15840 CLKBUF_X1
X$8896 VSS \$15666 \$14992 \$14696 \$15695 \$15917 VDD FA_X1
X$8897 \$15840 VSS VDD \$15548 CLKBUF_X1
X$8899 \$16054 VSS VDD \$15660 CLKBUF_X1
X$8900 \$15826 VSS VDD \$16054 CLKBUF_X1
X$8901 \$15829 VSS VDD \$16053 CLKBUF_X1
X$8903 \$15545 VSS VDD \$15828 CLKBUF_X1
X$8905 \$15916 \$16060 \$15666 VSS VDD \$15915 NAND3_X1
X$8906 \$15917 \$15695 \$16060 VDD VSS \$15698 HA_X1
X$8907 \$15696 \$16066 VDD VSS \$14828 XNOR2_X1
X$8908 \$15916 \$14992 VSS VDD \$15550 NAND2_X1
X$8909 \$15849 \$15699 \$15550 VSS \$15852 VDD AOI21_X1
X$8912 \$16068 VSS VDD \$15849 INV_X1
X$8913 \$15700 \$16134 \$15696 VSS \$15855 VDD AOI21_X1
X$8915 \$15852 \$15700 VSS VDD \$15394 OR2_X1
X$8916 \$15551 VSS VDD \$15395 CLKBUF_X1
X$8917 \$15553 \$15551 \$15853 VSS \$14996 VDD AOI21_X1
X$8920 VSS \$14252 \$I100347 \$15864 \$15555 \$15181 VDD DFFR_X1
X$8921 \$15864 VSS VDD \$15558 CLKBUF_X1
X$8924 \$15506 VSS VDD \$15870 CLKBUF_X1
X$8926 \$15855 VSS VDD \$15853 INV_X1
X$8927 \$16333 \$16404 \$15551 VDD VSS \$15553 HA_X1
X$8929 \$15922 VSS VDD \$16080 CLKBUF_X1
X$8930 \$16081 VSS VDD \$15555 CLKBUF_X1
X$8932 \$15556 VSS VDD \$15650 CLKBUF_X1
X$8935 \$15560 VSS VDD \$15509 CLKBUF_X3
X$8936 \$15870 VSS VDD \$15869 CLKBUF_X1
X$8939 \$15869 VSS VDD \$15868 CLKBUF_X1
X$8940 \$15868 VSS VDD \$15877 CLKBUF_X1
X$8941 \$15641 VSS VDD \$15874 CLKBUF_X1
X$8942 \$15874 VSS VDD \$16091 CLKBUF_X1
X$8943 \$15879 VSS VDD \$15638 CLKBUF_X1
X$8944 \$15701 VSS VDD \$15636 CLKBUF_X1
X$8945 \$15638 VSS VDD \$15701 CLKBUF_X1
X$8949 \$16091 VSS VDD \$15879 CLKBUF_X1
X$8951 \$15877 VSS VDD \$15881 CLKBUF_X1
X$8952 VSS \$15189 \$I100337 \$15706 \$15881 \$15181 VDD DFFR_X1
X$8953 \$15560 VSS VDD \$15189 CLKBUF_X3
X$8954 VSS \$15189 \$I100266 \$15626 \$15707 \$15181 VDD DFFR_X1
X$8955 VSS \$15007 \$I100247 \$15862 \$15871 \$15181 VDD DFFR_X1
X$8956 VSS \$15406 \$I100470 \$14884 \$15856 \$15181 VDD DFFR_X1
X$8957 \$9943 VSS VDD \$15406 CLKBUF_X3
X$8958 \$15838 VSS VDD \$15612 CLKBUF_X1
X$8959 \$15564 VSS VDD \$15714 CLKBUF_X1
X$8960 \$15614 VSS VDD \$15616 CLKBUF_X1
X$8961 \$15612 VSS VDD \$15614 CLKBUF_X1
X$8964 \$15566 VSS VDD \$15716 CLKBUF_X1
X$8966 \$15181 VSS VDD \$9850 BUF_X2
X$8973 \$15634 VSS VDD \$15703 CLKBUF_X1
X$8974 \$16099 VSS VDD \$15630 CLKBUF_X1
X$8975 \$15703 VSS VDD \$16099 CLKBUF_X1
X$8977 \$16102 VSS VDD \$15889 CLKBUF_X1
X$8978 \$15888 VSS VDD \$16103 CLKBUF_X1
X$8979 \$15887 VSS VDD \$16102 CLKBUF_X1
X$8980 \$15706 VSS VDD \$15888 CLKBUF_X1
X$8981 \$15889 VSS VDD \$15707 CLKBUF_X1
X$8982 \$16103 VSS VDD \$15887 CLKBUF_X1
X$8984 \$16094 VSS VDD \$15886 CLKBUF_X1
X$8985 \$15882 VSS VDD \$16090 CLKBUF_X1
X$8986 \$15873 VSS VDD \$16094 CLKBUF_X1
X$8987 \$15626 VSS VDD \$15882 CLKBUF_X1
X$8988 \$15886 VSS VDD \$15709 CLKBUF_X1
X$8989 \$16090 VSS VDD \$15873 CLKBUF_X1
X$8990 \$15709 VSS VDD \$15871 CLKBUF_X1
X$8991 \$15713 VSS VDD \$16077 CLKBUF_X1
X$8992 \$15932 VSS VDD \$15405 CLKBUF_X1
X$8993 \$2886 VSS VDD \$15560 CLKBUF_X3
X$8994 \$16075 VSS VDD \$16073 CLKBUF_X1
X$8995 \$15862 VSS VDD \$16075 CLKBUF_X1
X$8996 \$14700 VSS VDD \$14951 CLKBUF_X1
X$8997 \$16295 VSS VDD \$15856 CLKBUF_X1
X$8998 \$16073 VSS VDD \$15713 CLKBUF_X1
X$8999 \$15409 VSS VDD \$15564 CLKBUF_X1
X$9003 \$15714 VSS VDD \$15838 CLKBUF_X1
X$9004 \$15406 VSS VDD \$I68384 INV_X1
X$9006 VSS \$15406 \$I99800 \$16690 \$15196 \$9850 VDD DFFR_X1
X$9008 VSS \$15933 \$I99835 \$13678 \$16059 \$15181 VDD DFFR_X1
X$9009 VSS \$15933 \$15568 \$14273 \$15937 \$15181 VDD DFFR_X1
X$9011 \$15717 \$15605 \$15570 VDD VSS \$15606 HA_X1
X$9012 \$15568 VSS VDD \$15210 INV_X1
X$9017 \$16044 VSS VDD \$15717 INV_X1
X$9019 VSS \$15822 \$16044 \$15941 \$15594 \$16041 VDD FA_X1
X$9020 VSS \$15816 \$16040 \$15818 \$14543 \$14323 VDD FA_X1
X$9022 \$15818 VSS VDD \$15946 INV_X1
X$9026 \$16040 VSS VDD \$16041 INV_X1
X$9029 VSS \$15797 \$15822 \$15945 \$15018 \$15946 VDD FA_X1
X$9032 VSS \$15948 \$15816 \$16017 \$15812 \$15814 VDD FA_X1
X$9034 \$13571 \$14884 VDD VSS \$15814 AND2_X1
X$9035 \$14273 \$13872 VSS VDD \$15573 NAND2_X1
X$9036 \$15573 VSS VDD \$15812 INV_X1
X$9039 \$15791 VSS VDD \$15787 INV_X1
X$9041 \$16017 VSS VDD \$16016 INV_X1
X$9042 VSS \$15787 \$15797 \$16534 \$15769 \$16016 VDD FA_X1
X$9044 \$13995 VSS VDD \$I101697 INV_X2
X$9045 \$13037 VSS VDD \$13995 CLKBUF_X3
X$9047 \$15777 VSS VDD \$15575 INV_X1
X$9048 VSS \$15719 \$15791 \$15720 \$15793 \$15575 VDD FA_X1
X$9050 \$13678 \$13398 VSS VDD \$15777 NAND2_X1
X$9056 \$15576 VSS VDD \$16387 INV_X1
X$9057 \$13678 \$13033 VSS VDD \$16226 NAND2_X1
X$9059 \$14273 \$13033 VSS VDD \$16009 NAND2_X1
X$9060 \$13678 \$12651 VSS VDD \$15767 NAND2_X1
X$9061 \$16009 VSS VDD \$15956 INV_X1
X$9063 \$14884 \$13680 VSS VDD \$15726 NAND2_X1
X$9064 \$15726 VSS VDD \$16002 INV_X1
X$9065 \$14700 \$13398 VSS VDD \$15728 NAND2_X1
X$9066 \$15728 VSS VDD \$15958 INV_X1
X$9069 \$15577 VSS VDD \$15960 INV_X1
X$9070 \$14884 \$13398 VSS VDD \$15587 NAND2_X1
X$9078 \$14700 \$12651 VSS VDD \$15989 NAND2_X1
X$9082 \$15586 VSS VDD \$15971 INV_X1
X$9084 \$15989 VSS VDD \$15747 INV_X1
X$9094 \$19061 VSS VDD \$19140 CLKBUF_X1
X$9095 VSS \$18899 \$I100498 \$19220 \$19136 \$15672 VDD DFFR_X1
X$9096 \$17110 VSS VDD \$18899 CLKBUF_X3
X$9100 VSS \$18899 \$I100043 \$12523 \$19286 \$15672 VDD DFFR_X1
X$9101 \$19220 VSS VDD \$19037 CLKBUF_X1
X$9103 \$12523 VSS VDD \$19039 CLKBUF_X1
X$9104 \$19140 VSS VDD \$19038 CLKBUF_X1
X$9115 \$19040 VSS VDD \$19102 CLKBUF_X1
X$9116 VSS \$19381 \$I99971 \$19327 \$19103 \$15672 VDD DFFR_X1
X$9117 \$19149 VSS VDD \$18900 CLKBUF_X1
X$9118 \$19102 VSS VDD \$19103 CLKBUF_X1
X$9122 \$19151 VSS VDD \$18470 CLKBUF_X1
X$9126 \$18678 \$19231 VDD VSS \$19104 XNOR2_X1
X$9128 \$19228 \$19104 VSS VDD \$19229 XOR2_X1
X$9130 \$19229 \$19041 VDD VSS \$19232 XNOR2_X1
X$9133 VSS \$19234 \$19231 \$19322 \$19105 \$19182 VDD FA_X1
X$9134 \$18949 VSS VDD \$19105 INV_X1
X$9138 VSS \$18344 \$19235 \$19156 \$18002 \$19043 VDD FA_X1
X$9142 \$19235 VSS VDD \$19182 INV_X1
X$9145 VSS \$19184 \$19234 \$19417 \$19079 \$19183 VDD FA_X1
X$9146 \$19156 VSS VDD \$19183 INV_X1
X$9149 VSS \$18344 \$19185 \$19240 \$18002 \$18957 VDD FA_X1
X$9152 \$19185 VSS VDD \$19186 INV_X1
X$9155 VSS \$19188 \$19289 \$19189 \$18680 \$19187 VDD FA_X1
X$9156 VSS \$19164 \$19108 \$19160 \$18002 \$18344 VDD FA_X1
X$9158 \$19160 VSS VDD \$19085 INV_X1
X$9163 \$19240 VSS VDD \$19187 INV_X1
X$9165 \$19108 VSS VDD \$19290 INV_X1
X$9168 \$19046 VSS VDD \$19334 INV_X1
X$9171 \$19190 \$19293 VDD VSS \$19191 XNOR2_X1
X$9175 VSS \$19295 \$I100148 \$19391 \$19089 \$15541 VDD DFFR_X1
X$9176 VSS \$18905 \$I100119 \$19297 \$19357 \$15541 VDD DFFR_X1
X$9178 \$19110 VSS VDD \$19111 CLKBUF_X1
X$9181 \$19172 VSS VDD \$19093 CLKBUF_X1
X$9182 \$19092 VSS VDD \$19174 CLKBUF_X1
X$9183 \$17365 VSS VDD \$18905 CLKBUF_X3
X$9185 \$19174 VSS VDD \$19172 CLKBUF_X1
X$9186 \$19093 VSS VDD \$19179 CLKBUF_X1
X$9187 \$19113 VSS VDD \$19095 CLKBUF_X1
X$9188 VSS \$18905 \$I100294 \$19115 \$19114 \$16907 VDD DFFR_X1
X$9191 \$19116 VSS VDD \$19050 CLKBUF_X1
X$9194 VSS \$18485 \$I100322 \$19176 \$19117 \$16907 VDD DFFR_X1
X$9198 VSS \$18905 \$I99825 \$19366 \$19194 \$15541 VDD DFFR_X1
X$9199 \$19196 VSS VDD \$19114 CLKBUF_X1
X$9200 \$19179 VSS VDD \$19196 CLKBUF_X1
X$9201 \$19299 VSS VDD \$19395 CLKBUF_X1
X$9204 \$19115 VSS VDD \$19265 CLKBUF_X1
X$9205 \$19265 VSS VDD \$19266 CLKBUF_X1
X$9206 \$19266 VSS VDD \$19267 CLKBUF_X1
X$9207 \$19267 VSS VDD \$19271 CLKBUF_X1
X$9208 \$19269 \$19050 \$19049 VSS \$19197 VDD AOI21_X1
X$9209 \$19269 \$19116 \$18911 VSS \$19198 VDD AOI21_X1
X$9211 \$19270 VSS VDD \$19117 CLKBUF_X1
X$9212 \$19271 VSS VDD \$19270 CLKBUF_X1
X$9214 \$18260 VSS VDD \$18798 CLKBUF_X1
X$9216 \$19274 VSS VDD \$19166 CLKBUF_X1
X$9217 \$19176 VSS VDD \$19273 CLKBUF_X1
X$9218 \$19273 VSS VDD \$19277 CLKBUF_X1
X$9219 \$19277 VSS VDD \$19278 CLKBUF_X1
X$9220 \$19278 VSS VDD \$19279 CLKBUF_X1
X$9221 \$19168 VSS VDD \$19053 INV_X1
X$9225 \$19279 VSS VDD \$19367 CLKBUF_X1
X$9226 VSS \$19280 \$19199 \$19168 \$19260 \$19284 VDD FA_X1
X$9228 VSS \$18485 \$I100310 \$18624 \$19118 \$16907 VDD DFFR_X1
X$9229 VSS \$19200 \$19284 \$19120 \$19261 \$19119 VDD FA_X1
X$9230 VSS \$19121 \$19119 \$18802 \$19087 \$18701 VDD FA_X1
X$9233 \$19201 VSS VDD \$19200 INV_X1
X$9236 \$19121 VSS VDD \$19263 INV_X1
X$9237 \$19122 \$19263 \$19201 VDD VSS \$19361 HA_X1
X$9238 \$19159 VSS VDD \$19122 INV_X1
X$9242 \$19257 VSS VDD \$19261 INV_X1
X$9244 VSS \$19254 \$19356 \$19008 \$19245 \$19258 VDD FA_X1
X$9247 VSS \$19248 \$19257 \$19124 \$19250 \$19204 VDD FA_X1
X$9248 \$19123 VSS VDD \$19250 INV_X1
X$9249 \$18052 \$17559 VSS VDD \$19123 NAND2_X1
X$9251 \$19055 VSS VDD \$19248 INV_X1
X$9252 \$17010 \$18093 VSS VDD \$19055 NAND2_X1
X$9257 \$19243 VSS VDD \$19245 INV_X1
X$9258 VSS \$19244 \$19330 \$19243 \$19057 \$19206 VDD FA_X1
X$9259 \$19126 VSS VDD \$19244 INV_X1
X$9260 \$18624 \$17398 VSS VDD \$19126 NAND2_X1
X$9267 \$18701 \$17398 VSS VDD \$19321 NOR2_X1
X$9268 \$19238 VSS VDD \$19208 INV_X1
X$9269 \$18624 \$17559 VSS VDD \$19238 NAND2_X1
X$9270 \$19129 VSS VDD \$19316 INV_X1
X$9271 \$18260 \$18093 VSS VDD \$19129 NAND2_X1
X$9274 \$19212 VSS VDD \$19213 INV_X1
X$9275 \$18807 \$18915 \$19075 VDD VSS \$19146 HA_X1
X$9277 \$19146 VSS VDD \$19130 INV_X1
X$9278 \$19146 \$18926 VSS VDD \$19067 NAND2_X1
X$9279 \$18926 VSS VDD \$19131 CLKBUF_X1
X$9282 \$19075 VSS VDD \$19212 CLKBUF_X1
X$9283 \$18102 \$19213 VDD VSS \$19217 XNOR2_X1
X$9284 \$19213 \$18925 \$19130 VDD \$19214 VSS OAI21_X1
X$9285 \$19131 VSS VDD \$19215 INV_X1
X$9286 \$19214 \$19215 VDD VSS \$19144 XNOR2_X1
X$9287 VSS \$18501 \$I100097 \$18930 \$19217 \$16907 VDD DFFR_X1
X$9288 VSS \$18501 \$I100474 \$19065 \$19144 \$16907 VDD DFFR_X1
X$9293 \$19065 VSS VDD \$18815 CLKBUF_X1
X$9295 \$18437 \$18636 \$18915 VSS VDD NOR2_X4
X$9340 \$6497 VSS VDD \$6577 CLKBUF_X1
X$9341 \$6339 VSS VDD \$6590 CLKBUF_X1
X$9342 \$6787 VSS VDD \$6159 CLKBUF_X1
X$9343 VSS \$5715 \$I100344 \$6792 \$6499 \$3006 VDD DFFR_X1
X$9344 \$6503 VSS VDD \$6798 CLKBUF_X1
X$9346 \$6061 VSS VDD \$6596 CLKBUF_X1
X$9347 \$6419 VSS VDD \$6603 CLKBUF_X1
X$9348 \$6721 VSS VDD \$6805 CLKBUF_X1
X$9349 \$6608 VSS VDD \$6721 CLKBUF_X1
X$9350 VSS \$6340 \$I100306 \$6723 \$6809 \$3006 VDD DFFR_X1
X$9351 VSS \$6340 \$I100295 \$6726 \$6819 \$3006 VDD DFFR_X1
X$9352 \$6506 VSS VDD \$6508 CLKBUF_X1
X$9353 \$6507 VSS VDD \$6727 CLKBUF_X1
X$9354 \$6508 VSS VDD \$6618 CLKBUF_X1
X$9355 \$6619 VSS VDD \$6728 CLKBUF_X1
X$9356 \$6729 VSS VDD \$6068 CLKBUF_X1
X$9357 \$6344 VSS VDD \$6730 CLKBUF_X1
X$9358 \$6510 VSS VDD \$6625 CLKBUF_X1
X$9359 \$6627 VSS VDD \$7033 CLKBUF_X1
X$9360 VSS \$5366 \$I100154 \$6733 \$6511 \$3006 VDD DFFR_X1
X$9362 \$6631 VSS VDD \$6835 CLKBUF_X1
X$9363 \$6734 VSS VDD \$6735 CLKBUF_X1
X$9374 \$7002 VSS VDD \$6499 CLKBUF_X1
X$9375 \$6504 VSS VDD \$6787 CLKBUF_X1
X$9376 \$6792 VSS VDD \$6594 CLKBUF_X1
X$9377 \$6798 VSS VDD \$7005 CLKBUF_X1
X$9378 \$7005 VSS VDD \$7002 CLKBUF_X1
X$9379 \$7012 VSS VDD \$6503 CLKBUF_X1
X$9380 \$6795 VSS VDD \$7006 CLKBUF_X1
X$9381 \$6927 VSS VDD \$7012 CLKBUF_X1
X$9382 \$6806 VSS VDD \$7015 CLKBUF_X1
X$9383 \$7015 VSS VDD \$6795 CLKBUF_X1
X$9384 \$7014 VSS VDD \$7019 CLKBUF_X1
X$9385 \$6803 VSS VDD \$6929 CLKBUF_X1
X$9386 \$7022 VSS VDD \$6806 CLKBUF_X1
X$9387 \$6722 VSS VDD \$7022 CLKBUF_X1
X$9389 \$6805 VSS VDD \$6064 CLKBUF_X1
X$9390 \$6341 VSS VDD \$7024 CLKBUF_X1
X$9391 \$7024 VSS VDD \$6809 CLKBUF_X1
X$9393 \$6816 VSS VDD \$7026 CLKBUF_X1
X$9394 \$6723 VSS VDD \$6816 CLKBUF_X1
X$9395 \$7026 VSS VDD \$6932 CLKBUF_X1
X$9396 \$6933 VSS VDD \$7028 CLKBUF_X1
X$9397 \$7028 VSS VDD \$6819 CLKBUF_X1
X$9400 \$7027 VSS VDD \$6506 CLKBUF_X1
X$9401 \$6726 VSS VDD \$6507 CLKBUF_X1
X$9402 \$6727 VSS VDD \$7027 CLKBUF_X1
X$9406 \$6728 VSS VDD \$6729 CLKBUF_X1
X$9407 \$6730 VSS VDD \$6509 CLKBUF_X1
X$9410 \$7033 VSS VDD \$7038 CLKBUF_X1
X$9411 \$6936 VSS VDD \$6511 CLKBUF_X1
X$9412 \$6625 VSS VDD \$6936 CLKBUF_X1
X$9413 \$7038 VSS VDD \$6510 CLKBUF_X1
X$9414 \$6835 VSS VDD \$6732 CLKBUF_X1
X$9415 \$7167 VSS VDD \$7043 CLKBUF_X1
X$9417 \$6735 VSS VDD \$6832 CLKBUF_X1
X$9418 \$6733 VSS VDD \$6734 CLKBUF_X1
X$9421 \$3006 VDD \$6364 VSS BUF_X4
X$9422 \$6075 VSS VDD \$6205 CLKBUF_X1
X$9423 \$6512 VSS VDD \$6513 CLKBUF_X1
X$9424 VSS \$6440 \$I100207 \$6846 \$6844 \$3833 VDD DFFR_X1
X$9426 \$6846 VSS VDD \$6849 CLKBUF_X1
X$9429 \$7047 VSS VDD \$6844 CLKBUF_X1
X$9432 \$6076 VSS VDD \$6940 CLKBUF_X1
X$9433 \$6849 VSS VDD \$7060 CLKBUF_X1
X$9434 \$7060 VSS VDD \$6941 CLKBUF_X1
X$9435 \$7062 VSS VDD \$6741 CLKBUF_X1
X$9436 \$6738 VSS VDD \$7062 CLKBUF_X1
X$9437 VSS \$5735 \$I100191 \$6743 \$4017 \$3833 VDD DFFR_X1
X$9438 VSS \$5735 \$I100210 \$7065 \$6741 \$3833 VDD DFFR_X1
X$9439 \$6663 VSS VDD \$6744 CLKBUF_X1
X$9440 \$6744 VSS VDD \$6351 CLKBUF_X1
X$9441 \$6667 VSS VDD \$6471 CLKBUF_X1
X$9444 VSS \$6440 \$6942 \$6943 \$4049 \$3833 VDD DFFR_X1
X$9446 \$7065 VSS VDD \$6350 CLKBUF_X1
X$9448 \$6516 VSS VDD \$6742 CLKBUF_X1
X$9450 \$6517 VSS VDD \$6861 CLKBUF_X1
X$9453 \$6520 VSS VDD \$5579 CLKBUF_X1
X$9456 \$6678 VSS VDD \$6675 CLKBUF_X1
X$9457 \$6865 VSS VDD \$6871 CLKBUF_X1
X$9458 \$6352 VSS VDD \$6678 CLKBUF_X1
X$9459 \$5493 VSS VDD \$6087 CLKBUF_X3
X$9462 \$6946 VSS VDD \$6947 CLKBUF_X1
X$9464 \$6745 VSS VDD \$6865 CLKBUF_X1
X$9465 \$6871 VSS VDD \$6478 CLKBUF_X1
X$9467 \$6688 VSS VDD \$7074 CLKBUF_X1
X$9468 \$6250 VSS VDD \$6086 CLKBUF_X1
X$9469 \$6880 VSS VDD \$5910 CLKBUF_X1
X$9470 \$5493 VSS VDD \$I98972 CLKBUF_X3
X$9471 \$2886 VSS VDD \$5493 CLKBUF_X3
X$9472 VSS \$6883 \$5583 \$I87283 \$6887 \$6364 VDD DFFR_X1
X$9476 \$6255 VSS VDD \$6258 CLKBUF_X1
X$9477 \$6257 VSS VDD \$6524 CLKBUF_X1
X$9478 \$7074 VSS VDD \$6880 CLKBUF_X1
X$9479 \$6526 VSS VDD \$6527 CLKBUF_X1
X$9480 \$6355 VSS VDD \$7478 CLKBUF_X1
X$9481 \$7084 VSS VDD \$7085 CLKBUF_X1
X$9482 \$7082 VSS VDD \$6887 CLKBUF_X1
X$9483 VSS \$6883 \$I99975 \$7092 \$6356 \$6364 VDD DFFR_X1
X$9490 VSS \$5744 \$I100083 \$7100 \$5194 \$6364 VDD DFFR_X1
X$9491 \$6530 \$6364 VSS VDD \$6518 NAND2_X1
X$9493 \$5744 VSS VDD \$I101705 INV_X2
X$9494 \$5493 VSS VDD \$5744 CLKBUF_X3
X$9495 \$6530 VSS VDD \$6529 INV_X1
X$9499 \$7101 VSS VDD \$7106 CLKBUF_X1
X$9500 \$7106 VSS VDD \$6951 CLKBUF_X1
X$9503 VSS \$5744 \$I100142 \$6952 \$6911 \$6364 VDD DFFR_X1
X$9504 \$6752 VSS VDD \$6911 CLKBUF_X1
X$9505 \$6910 VSS VDD \$6531 CLKBUF_X1
X$9506 \$6531 VSS VDD \$6752 CLKBUF_X1
X$9508 \$6532 VSS VDD \$6912 CLKBUF_X1
X$9509 \$6912 VSS VDD \$7115 CLKBUF_X1
X$9510 \$4451 VSS VDD \$6753 CLKBUF_X1
X$9513 \$7115 VSS VDD \$6910 CLKBUF_X1
X$9516 VSS \$6755 \$6920 \$6473 \$6954 \$6364 VDD DFFR_X1
X$9517 \$6534 VSS VDD \$6754 CLKBUF_X1
X$9519 \$7121 \$6714 \$6530 VDD VSS \$6361 HA_X1
X$9520 \$6361 VSS VDD \$6715 INV_X1
X$9521 \$6921 VSS VDD \$6922 CLKBUF_X1
X$9525 VSS \$6755 \$I100504 \$6756 \$6536 \$6364 VDD DFFR_X1
X$9526 VSS \$4525 \$I100506 \$5334 \$6918 \$6364 VDD DFFR_X1
X$9527 \$4525 VSS VDD \$I101702 INV_X2
X$9533 \$6756 VSS VDD \$7129 CLKBUF_X1
X$9534 \$7129 VSS VDD \$6957 CLKBUF_X1
X$9536 \$6757 VSS VDD \$6758 CLKBUF_X1
X$9539 \$6759 VSS VDD \$7295 CLKBUF_X1
X$9542 \$6763 VSS VDD \$327 BUF_X2
X$9549 VSS \$6762 \$I100237 \$6709 \$6761 \$6763 VDD DFFR_X1
X$9551 \$6895 VSS VDD \$7147 CLKBUF_X1
X$9552 \$6898 VSS VDD \$6765 CLKBUF_X1
X$9554 \$6762 VSS VDD \$I101708 INV_X2
X$9555 \$6892 VSS VDD \$6705 CLKBUF_X1
X$9558 \$6885 VSS VDD \$6544 CLKBUF_X1
X$9559 \$6543 VSS VDD \$6366 CLKBUF_X1
X$9560 \$6545 VSS VDD \$6885 CLKBUF_X1
X$9563 \$7147 VSS VDD \$6761 CLKBUF_X1
X$9564 \$7286 VSS VDD \$7526 CLKBUF_X1
X$9565 VSS \$6762 \$I100050 \$7155 \$6963 \$6763 VDD DFFR_X1
X$9566 \$7153 VSS VDD \$6895 CLKBUF_X1
X$9567 \$5666 VSS VDD \$6762 CLKBUF_X3
X$9568 \$6966 VSS VDD \$6457 CLKBUF_X1
X$9570 VSS \$6762 \$I99973 \$6367 \$7144 \$4734 VDD DFFR_X1
X$9571 VSS \$6762 \$I100391 \$6877 \$6881 \$4734 VDD DFFR_X1
X$9573 \$6877 VSS VDD \$6547 CLKBUF_X1
X$9574 \$7142 VSS VDD \$5931 CLKBUF_X1
X$9575 \$6547 VSS VDD \$6684 CLKBUF_X1
X$9586 \$7141 VSS VDD \$6876 CLKBUF_X1
X$9587 \$6968 VSS VDD \$7141 CLKBUF_X1
X$9588 VSS \$7193 \$I99893 \$7137 \$6969 \$4734 VDD DFFR_X1
X$9589 \$6864 VSS VDD \$6857 CLKBUF_X1
X$9590 VSS \$6116 \$I100355 \$6864 \$6856 \$4734 VDD DFFR_X1
X$9591 \$6857 VSS VDD \$6860 CLKBUF_X1
X$9592 \$6860 VSS VDD \$6674 CLKBUF_X1
X$9594 \$7137 VSS VDD \$6971 CLKBUF_X1
X$9596 \$7136 VSS VDD \$6867 CLKBUF_X1
X$9597 \$6971 VSS VDD \$7136 CLKBUF_X1
X$9598 \$6679 VSS VDD \$7131 CLKBUF_X1
X$9599 \$7131 VSS VDD \$6856 CLKBUF_X1
X$9600 \$7200 VSS VDD \$7133 CLKBUF_X1
X$9601 \$5415 VSS VDD \$6116 CLKBUF_X3
X$9602 VSS \$6116 \$I100152 \$4307 \$6550 \$4734 VDD DFFR_X1
X$9609 \$7123 VSS VDD \$6972 CLKBUF_X1
X$9610 \$6973 VSS VDD \$6550 CLKBUF_X1
X$9613 \$6975 VSS VDD \$7114 CLKBUF_X1
X$9614 \$7114 VSS VDD \$7117 CLKBUF_X1
X$9615 \$7117 VSS VDD \$7110 CLKBUF_X1
X$9617 \$7105 VSS VDD \$6848 CLKBUF_X1
X$9618 VSS \$5988 \$I100032 \$6977 \$7254 \$6120 VDD DFFR_X1
X$9619 \$6843 VSS VDD \$7105 CLKBUF_X1
X$9620 \$6848 VSS VDD \$6552 CLKBUF_X1
X$9621 \$6552 VSS VDD \$6655 CLKBUF_X1
X$9623 \$6840 VSS VDD \$6369 CLKBUF_X1
X$9624 \$6770 VSS VDD \$6771 CLKBUF_X1
X$9627 \$6555 VSS VDD \$6372 CLKBUF_X1
X$9628 \$6553 VSS VDD \$6554 CLKBUF_X1
X$9630 \$6829 VSS VDD \$7080 CLKBUF_X1
X$9633 \$6825 VSS VDD \$6824 CLKBUF_X1
X$9634 \$6824 VSS VDD \$6827 CLKBUF_X1
X$9635 \$6827 VSS VDD \$6629 CLKBUF_X1
X$9636 VSS \$6773 \$I100359 \$6818 \$6774 \$6120 VDD DFFR_X1
X$9637 \$6818 VSS VDD \$6558 CLKBUF_X1
X$9639 \$6978 VSS VDD \$7090 CLKBUF_X1
X$9640 \$7090 VSS VDD \$6770 CLKBUF_X1
X$9641 \$6771 VSS VDD \$6840 CLKBUF_X1
X$9643 \$6772 VSS VDD \$5935 CLKBUF_X1
X$9645 \$7075 VSS VDD \$7072 CLKBUF_X1
X$9646 VSS \$6773 \$I99871 \$7067 \$7080 \$6120 VDD DFFR_X1
X$9647 \$7067 VSS VDD \$7061 CLKBUF_X1
X$9648 \$7061 VSS VDD \$7063 CLKBUF_X1
X$9649 \$7063 VSS VDD \$6825 CLKBUF_X1
X$9650 \$7056 VSS VDD \$7055 CLKBUF_X1
X$9651 \$7053 VSS VDD \$7056 CLKBUF_X1
X$9653 VSS \$7233 \$I100139 \$7045 \$7050 \$6120 VDD DFFR_X1
X$9654 \$6812 VSS VDD \$6606 CLKBUF_X1
X$9655 VSS \$5000 \$I100446 \$6799 \$6561 \$6120 VDD DFFR_X1
X$9656 \$6799 VSS VDD \$6810 CLKBUF_X1
X$9657 \$6810 VSS VDD \$6813 CLKBUF_X1
X$9658 \$6813 VSS VDD \$6610 CLKBUF_X1
X$9662 \$7045 VSS VDD \$7046 CLKBUF_X1
X$9663 \$7046 VSS VDD \$7030 CLKBUF_X1
X$9664 \$6777 VSS VDD \$6778 CLKBUF_X1
X$9665 \$6779 VSS VDD \$6777 CLKBUF_X1
X$9666 \$6778 VSS VDD \$6561 CLKBUF_X1
X$9667 \$7029 VSS VDD \$6402 CLKBUF_X1
X$9670 \$6379 \$6381 VSS VDD \$6790 NAND2_X1
X$9672 \$6782 VSS VDD \$6585 INV_X1
X$9673 \$6380 \$6563 VSS VDD \$6782 NAND2_X1
X$9674 \$7212 \$6564 VSS VDD \$6783 NAND2_X1
X$9675 \$6783 VSS VDD \$6786 INV_X1
X$9677 \$6786 \$6585 \$6996 VDD VSS \$6784 HA_X1
X$9688 \$6790 VSS VDD \$7007 INV_X1
X$9690 \$6566 \$6988 \$6999 VDD VSS \$6990 HA_X1
X$9691 \$6784 VSS VDD \$6989 INV_X1
X$9692 \$6996 \$6999 \$6568 VDD VSS \$7001 HA_X1
X$9693 \$7001 VSS VDD \$6991 INV_X1
X$9717 \$6994 VSS VDD \$7307 CLKBUF_X1
X$9718 \$7218 VSS VDD \$7390 CLKBUF_X1
X$9719 \$7160 VSS VDD \$7218 CLKBUF_X1
X$9720 \$6998 VSS VDD \$7220 CLKBUF_X1
X$9722 \$6993 VSS VDD \$6994 CLKBUF_X1
X$9723 \$7399 VSS VDD \$7398 CLKBUF_X1
X$9724 \$6926 VSS VDD \$6998 CLKBUF_X1
X$9725 \$7000 VSS VDD \$7161 CLKBUF_X1
X$9726 \$7220 VSS VDD \$7000 CLKBUF_X1
X$9727 VSS \$6340 \$I100441 \$6927 \$7006 \$3006 VDD DFFR_X1
X$9728 VSS \$6340 \$I100297 \$7164 \$6929 \$3006 VDD DFFR_X1
X$9730 \$6180 VSS VDD \$6340 CLKBUF_X3
X$9732 \$7398 VSS VDD \$7308 CLKBUF_X1
X$9733 \$7161 VSS VDD \$7399 CLKBUF_X1
X$9734 \$7223 VSS VDD \$7309 CLKBUF_X1
X$9735 \$7403 VSS VDD \$7223 CLKBUF_X1
X$9737 \$7310 VSS VDD \$7403 CLKBUF_X1
X$9739 VSS \$5715 \$I100053 \$7410 \$7405 \$3006 VDD DFFR_X1
X$9740 \$7411 VSS VDD \$7014 CLKBUF_X1
X$9741 \$7019 VSS VDD \$6803 CLKBUF_X1
X$9743 \$7164 VSS VDD \$6722 CLKBUF_X1
X$9744 \$7417 VSS VDD \$7411 CLKBUF_X1
X$9746 VSS \$6340 \$I100117 \$7312 \$961 \$3006 VDD DFFR_X1
X$9748 \$6932 VSS VDD \$6933 CLKBUF_X1
X$9753 VSS \$5366 \$I99991 \$7316 \$7425 \$3006 VDD DFFR_X1
X$9754 VSS \$6440 \$I100268 \$7169 \$7043 \$3006 VDD DFFR_X1
X$9755 \$7315 VSS VDD \$7166 CLKBUF_X1
X$9757 \$7243 VSS VDD \$7048 CLKBUF_X1
X$9758 \$7247 VSS VDD \$7052 CLKBUF_X1
X$9759 \$7052 VSS VDD \$7243 CLKBUF_X1
X$9760 \$7048 VSS VDD \$7047 CLKBUF_X1
X$9761 \$6440 VSS VDD \$I93828 CLKBUF_X1
X$9762 \$6180 VSS VDD \$6440 CLKBUF_X3
X$9763 \$6939 VSS VDD \$7170 INV_X1
X$9766 \$6941 VSS VDD \$6738 CLKBUF_X1
X$9769 \$6943 VSS VDD \$7323 CLKBUF_X1
X$9771 \$6743 VSS VDD \$7068 CLKBUF_X1
X$9772 \$7068 VSS VDD \$7172 CLKBUF_X1
X$9774 \$7261 VSS VDD \$6945 CLKBUF_X1
X$9775 VSS \$6087 \$I100241 \$7174 \$6945 \$6364 VDD DFFR_X1
X$9776 VSS \$6087 \$I100377 \$7175 \$7267 \$6364 VDD DFFR_X1
X$9778 \$7086 VSS VDD \$7084 CLKBUF_X1
X$9779 \$7176 VSS VDD \$7086 CLKBUF_X1
X$9780 \$7085 VSS VDD \$7082 CLKBUF_X1
X$9782 \$7092 VSS VDD \$7091 CLKBUF_X1
X$9783 \$7091 VSS VDD \$7094 CLKBUF_X1
X$9784 \$7274 VSS VDD \$6949 CLKBUF_X1
X$9785 \$7097 VSS VDD \$7180 CLKBUF_X1
X$9786 \$6949 VSS VDD \$7097 CLKBUF_X1
X$9787 \$7094 VSS VDD \$7274 CLKBUF_X1
X$9789 VSS \$6440 \$I99931 \$7683 \$1315 \$3006 VDD DFFR_X1
X$9790 \$6642 VSS VDD \$7318 CLKBUF_X1
X$9791 \$7169 VSS VDD \$7247 CLKBUF_X1
X$9792 VSS \$6440 \$I99818 \$7568 \$2644 \$6364 VDD DFFR_X1
X$9793 \$7570 VSS VDD \$7322 CLKBUF_X1
X$9797 VSS \$6440 \$I99798 \$7324 \$7441 \$6364 VDD DFFR_X1
X$9798 \$6942 VSS VDD \$7458 CLKBUF_X1
X$9801 \$7459 VSS VDD \$7325 CLKBUF_X1
X$9802 VSS \$6087 \$I99913 \$7326 \$7462 \$6364 VDD DFFR_X1
X$9804 \$7469 VSS VDD \$6946 CLKBUF_X1
X$9805 \$6947 VSS VDD \$7261 CLKBUF_X1
X$9806 \$7577 VSS VDD \$7469 CLKBUF_X1
X$9807 \$7468 VSS VDD \$7471 CLKBUF_X1
X$9808 \$7328 VSS VDD \$7330 CLKBUF_X1
X$9809 \$7174 VSS VDD \$7328 CLKBUF_X1
X$9810 \$7330 VSS VDD \$7468 CLKBUF_X1
X$9811 \$7471 VSS VDD \$7476 CLKBUF_X1
X$9812 \$7476 VSS VDD \$7267 CLKBUF_X1
X$9815 \$7175 VSS VDD \$7176 CLKBUF_X1
X$9816 \$7478 VSS VDD \$7734 CLKBUF_X1
X$9819 \$6883 VSS VDD \$I91965 CLKBUF_X1
X$9824 \$7333 VSS VDD \$7486 CLKBUF_X1
X$9826 VSS \$6883 \$I100085 \$7497 \$7180 \$6364 VDD DFFR_X1
X$9827 \$7100 VSS VDD \$7182 CLKBUF_X1
X$9828 \$7182 VSS VDD \$7101 CLKBUF_X1
X$9829 VSS \$5744 \$I100450 \$7288 \$7279 \$6364 VDD DFFR_X1
X$9832 \$7113 VSS VDD \$7517 CLKBUF_X1
X$9833 \$7291 VSS VDD \$7116 CLKBUF_X1
X$9834 \$7116 VSS VDD \$7337 CLKBUF_X1
X$9835 \$6952 VSS VDD \$7113 CLKBUF_X1
X$9837 \$7500 VSS VDD \$7747 CLKBUF_X1
X$9838 \$7493 VSS VDD \$7500 CLKBUF_X1
X$9839 \$6951 VSS VDD \$7502 CLKBUF_X1
X$9840 \$7502 VSS VDD \$7279 CLKBUF_X1
X$9842 \$7508 VSS VDD \$7506 CLKBUF_X1
X$9843 \$7507 VSS VDD \$7511 CLKBUF_X1
X$9844 \$7511 VSS VDD \$8017 CLKBUF_X1
X$9845 \$7288 VSS VDD \$7508 CLKBUF_X1
X$9848 \$7517 VSS VDD \$7291 CLKBUF_X1
X$9849 VSS \$6755 \$I99928 \$7339 \$7336 \$6364 VDD DFFR_X1
X$9850 \$6535 VSS VDD \$7187 CLKBUF_X1
X$9851 VSS \$6755 \$I100171 \$7121 \$7338 \$6364 VDD DFFR_X1
X$9853 VSS \$6755 \$I100216 \$5753 \$7342 \$6364 VDD DFFR_X1
X$9854 \$6957 VSS VDD \$6757 CLKBUF_X1
X$9856 \$5493 VSS VDD \$6755 CLKBUF_X3
X$9858 VSS \$6755 \$I100042 \$7306 \$6922 \$6364 VDD DFFR_X1
X$9859 \$7531 VSS VDD \$7344 CLKBUF_X1
X$9860 \$7306 VSS VDD \$7534 CLKBUF_X1
X$9863 VSS \$4525 \$I100500 \$7298 \$7132 \$6763 VDD DFFR_X1
X$9864 \$6758 VSS VDD \$7132 CLKBUF_X1
X$9865 VSS \$7189 \$I100178 \$6958 \$7138 \$327 VDD DFFR_X1
X$9869 \$7297 VSS VDD \$7548 CLKBUF_X1
X$9870 \$7546 VSS VDD \$7296 CLKBUF_X1
X$9871 \$7298 VSS VDD \$7546 CLKBUF_X1
X$9872 \$5157 VSS VDD \$7798 CLKBUF_X1
X$9873 \$7295 VSS VDD \$7349 CLKBUF_X1
X$9875 \$7548 VSS VDD \$7350 CLKBUF_X1
X$9876 \$7296 VSS VDD \$7297 CLKBUF_X1
X$9877 \$7350 VSS VDD \$7138 CLKBUF_X1
X$9879 \$6958 VSS VDD \$6959 CLKBUF_X1
X$9880 \$7536 VSS VDD \$7805 CLKBUF_X1
X$9881 \$7802 VSS VDD \$7539 CLKBUF_X1
X$9882 \$6959 VSS VDD \$7139 CLKBUF_X1
X$9884 \$7139 VSS VDD \$7536 CLKBUF_X1
X$9887 \$6960 VSS VDD \$7353 CLKBUF_X1
X$9891 \$7538 VSS VDD \$7537 CLKBUF_X1
X$9892 VSS \$7189 \$I100058 \$7533 \$7537 \$6763 VDD DFFR_X1
X$9893 VSS \$7189 \$I99982 \$7354 \$7528 \$6763 VDD DFFR_X1
X$9894 VSS \$7189 \$I100282 \$7191 \$6961 \$6763 VDD DFFR_X1
X$9896 \$6964 VSS VDD \$6965 CLKBUF_X1
X$9898 VSS \$6762 \$I100230 \$6966 \$7149 \$6763 VDD DFFR_X1
X$9899 \$6765 VSS VDD \$7153 CLKBUF_X1
X$9900 \$7155 VSS VDD \$6898 CLKBUF_X1
X$9901 \$7516 VSS VDD \$6892 CLKBUF_X1
X$9905 \$7355 VSS VDD \$6963 CLKBUF_X1
X$9906 \$7526 VSS VDD \$7355 CLKBUF_X1
X$9907 \$7191 VSS VDD \$6964 CLKBUF_X1
X$9908 \$7354 VSS VDD \$7519 CLKBUF_X1
X$9909 \$6965 VSS VDD \$7286 CLKBUF_X1
X$9911 \$7356 VSS VDD \$7520 CLKBUF_X1
X$9912 \$7520 VSS VDD \$7521 CLKBUF_X1
X$9913 \$7776 VSS VDD \$7149 CLKBUF_X1
X$9915 \$7519 VSS VDD \$7513 CLKBUF_X1
X$9919 \$7768 VSS VDD \$5837 CLKBUF_X1
X$9921 \$7192 VSS VDD \$7144 CLKBUF_X1
X$9922 VSS \$7193 \$I100408 \$7140 \$7277 \$4734 VDD DFFR_X1
X$9923 \$7140 VSS VDD \$6968 CLKBUF_X1
X$9925 \$7196 VSS VDD \$7142 CLKBUF_X1
X$9927 \$7504 VSS VDD \$7512 CLKBUF_X1
X$9928 \$7512 VSS VDD \$7192 CLKBUF_X1
X$9929 \$7513 VSS VDD \$7275 CLKBUF_X1
X$9931 \$7499 VSS VDD \$7504 CLKBUF_X1
X$9932 \$7194 VSS VDD \$7496 CLKBUF_X1
X$9933 \$7496 VSS VDD \$7499 CLKBUF_X1
X$9934 \$7494 VSS VDD \$7277 CLKBUF_X1
X$9938 \$7193 VSS VDD \$I91790 CLKBUF_X1
X$9939 \$7275 VSS VDD \$7481 CLKBUF_X1
X$9941 \$7197 VSS VDD \$7196 CLKBUF_X1
X$9942 \$7611 VSS VDD \$6969 CLKBUF_X1
X$9943 VSS \$6116 \$I100179 \$7126 \$7133 \$4734 VDD DFFR_X1
X$9944 VSS \$7193 \$I100534 \$7199 \$7270 \$4734 VDD DFFR_X1
X$9945 \$7126 VSS VDD \$7125 CLKBUF_X1
X$9946 \$7125 VSS VDD \$7128 CLKBUF_X1
X$9947 \$7128 VSS VDD \$7123 CLKBUF_X1
X$9948 \$6972 VSS VDD \$6973 CLKBUF_X1
X$9951 \$7483 VSS VDD \$7485 CLKBUF_X1
X$9952 \$7485 VSS VDD \$7487 CLKBUF_X1
X$9953 \$7487 VSS VDD \$7270 CLKBUF_X1
X$9956 \$7359 VSS VDD \$7474 CLKBUF_X1
X$9957 \$7199 VSS VDD \$7359 CLKBUF_X1
X$9958 \$7481 VSS VDD \$7460 CLKBUF_X1
X$9959 \$7474 VSS VDD \$7360 CLKBUF_X1
X$9960 \$7473 VSS VDD \$7200 CLKBUF_X1
X$9961 \$7360 VSS VDD \$7473 CLKBUF_X1
X$9962 VSS \$6116 \$I99822 \$7363 \$7467 \$4734 VDD DFFR_X1
X$9964 VSS \$6116 \$I100324 \$7104 \$7110 \$4734 VDD DFFR_X1
X$9965 VSS \$6116 \$I99902 \$7445 \$7460 \$4734 VDD DFFR_X1
X$9967 \$7447 VSS VDD \$7710 CLKBUF_X1
X$9968 \$7255 VSS VDD \$6976 CLKBUF_X1
X$9969 \$7104 VSS VDD \$6843 CLKBUF_X1
X$9971 \$6977 VSS VDD \$6978 CLKBUF_X1
X$9972 VSS \$6773 \$I100476 \$7439 \$7202 \$6120 VDD DFFR_X1
X$9974 VSS \$6773 \$I100087 \$7365 \$7442 \$6120 VDD DFFR_X1
X$9978 \$7367 VSS VDD \$7368 CLKBUF_X1
X$9979 \$7439 VSS VDD \$7240 CLKBUF_X1
X$9981 \$7071 VSS VDD \$7075 CLKBUF_X1
X$9982 \$7369 VSS VDD \$7203 CLKBUF_X1
X$9983 VSS \$6773 \$I99885 \$7373 \$7203 \$6120 VDD DFFR_X1
X$9984 \$7240 VSS VDD \$7071 CLKBUF_X1
X$9985 \$5415 VSS VDD \$6773 CLKBUF_X3
X$9986 \$7072 VSS VDD \$6829 CLKBUF_X1
X$9988 \$7234 VSS VDD \$7053 CLKBUF_X1
X$9989 \$6984 VSS VDD \$6125 CLKBUF_X1
X$9990 VSS \$6773 \$I100161 \$6381 \$7055 \$6120 VDD DFFR_X1
X$9991 \$8197 VSS VDD \$5940 CLKBUF_X1
X$9992 \$6381 VSS VDD \$7042 CLKBUF_X1
X$9993 \$7042 VSS VDD \$7041 CLKBUF_X1
X$9995 \$7229 VSS VDD \$7226 CLKBUF_X1
X$9996 \$7414 VSS VDD \$7029 CLKBUF_X1
X$9997 \$7041 VSS VDD \$6814 CLKBUF_X1
X$9998 \$7030 VSS VDD \$6779 CLKBUF_X1
X$10000 \$6986 \$6987 VSS VDD \$7214 NAND2_X1
X$10001 \$7214 VSS VDD \$6995 INV_X1
X$10003 \$6995 \$7007 \$6988 VDD VSS \$7393 HA_X1
X$10011 \$7204 VSS VDD \$7372 CLKBUF_X1
X$10012 \$7373 VSS VDD \$7429 CLKBUF_X1
X$10013 \$7429 VSS VDD \$7375 CLKBUF_X1
X$10014 VSS \$6773 \$I99959 \$7378 \$7206 \$6120 VDD DFFR_X1
X$10015 VSS \$5000 \$I99906 \$2371 \$7413 \$6120 VDD DFFR_X1
X$10018 \$6564 \$8168 VSS VDD \$7209 NAND2_X1
X$10020 \$7209 VSS VDD \$7400 INV_X1
X$10021 \$6381 \$6380 VSS VDD \$7219 NAND2_X1
X$10023 \$6563 \$7212 VSS VDD \$7213 NAND2_X1
X$10025 \$7213 VSS VDD \$7638 INV_X1
X$10026 \$7219 VSS VDD \$7396 INV_X1
X$10030 \$7393 VSS VDD \$7383 INV_X1
X$10031 \$6990 VSS VDD \$7387 INV_X1
X$10033 \$7391 VSS VDD \$7385 INV_X1
X$10034 \$7384 VSS VDD \$7216 INV_X1
X$10035 VSS \$6991 \$8664 \$7890 \$7216 \$7387 VDD FA_X1
X$10050 xin[2] VSS VDD \$19981 BUF_X1
X$10052 VSS \$19730 \$I100280 \$20000 \$20024 \$15672 VDD DFFR_X1
X$10053 \$20008 VSS VDD \$20006 CLKBUF_X1
X$10054 \$20006 VSS VDD \$19993 CLKBUF_X1
X$10055 \$20007 VSS VDD \$20008 CLKBUF_X1
X$10066 \$20018 VSS VDD \$19983 INV_X1
X$10069 \$20017 \$19984 VDD VSS \$19998 XNOR2_X1
X$10070 \$20010 \$20001 VDD VSS \$19984 XNOR2_X1
X$10072 reset VSS VDD \$15672 CLKBUF_X3
X$10089 \$20034 VSS VDD \$20007 CLKBUF_X1
X$10090 \$20000 VSS VDD \$20034 CLKBUF_X1
X$10105 VSS \$19985 \$20025 \$20018 \$19988 \$19997 VDD FA_X1
X$10106 \$19811 \$20019 VDD VSS \$20041 XNOR2_X1
X$10107 VSS \$19986 \$20019 \$19990 \$20005 \$20001 VDD FA_X1
X$10109 \$19811 VSS VDD \$20026 INV_X1
X$10128 \$20040 \$20025 VDD VSS \$20038 XNOR2_X1
X$10129 \$20041 \$20038 VSS VDD \$20017 XOR2_X1
X$10133 VSS \$19818 \$20040 \$20045 \$20026 \$19929 VDD FA_X1
X$10134 \$20045 VSS VDD \$20005 INV_X1
X$10169 xin[0] VSS VDD \$19136 BUF_X1
X$10174 \$19312 VSS VDD \$19437 CLKBUF_X1
X$10175 \$19380 VSS VDD \$19286 CLKBUF_X1
X$10179 VSS \$19381 \$I100353 \$19382 \$18388 \$15672 VDD DFFR_X1
X$10193 VSS \$18899 \$I100034 \$19436 \$19509 \$15672 VDD DFFR_X1
X$10195 \$19437 VSS VDD \$19380 CLKBUF_X1
X$10196 \$19531 VSS VDD \$19312 CLKBUF_X1
X$10200 VSS \$19381 \$I100035 \$19510 \$17046 \$15672 VDD DFFR_X1
X$10204 \$19609 VSS VDD \$19439 CLKBUF_X1
X$10206 \$17110 VSS VDD \$19381 CLKBUF_X3
X$10207 \$19382 VSS VDD \$19466 CLKBUF_X1
X$10208 \$19466 VSS VDD \$19288 CLKBUF_X1
X$10209 \$19383 VSS VDD \$19511 CLKBUF_X1
X$10211 \$19288 VSS VDD \$19383 CLKBUF_X1
X$10212 \$19415 \$19232 VDD VSS \$19384 XNOR2_X1
X$10216 \$19440 VSS VDD \$19441 CLKBUF_X1
X$10217 VSS \$19381 \$I99996 \$19479 \$19441 \$15672 VDD DFFR_X1
X$10220 \$18072 \$19384 VSS VDD \$19442 NAND2_X1
X$10221 \$19384 \$18072 VSS VDD \$19443 OR2_X1
X$10222 \$19442 \$19443 VSS VDD \$19625 NAND2_X1
X$10227 \$19322 VSS VDD \$19553 INV_X1
X$10228 \$19327 VSS VDD \$19337 CLKBUF_X1
X$10229 VSS \$19289 \$19385 \$19420 \$19417 \$19186 VDD FA_X1
X$10231 VSS \$19045 \$19482 \$19329 \$19189 \$19290 VDD FA_X1
X$10233 \$19385 VSS VDD \$19556 INV_X1
X$10238 \$19420 VSS VDD \$19483 INV_X1
X$10241 \$19482 VSS VDD \$19387 INV_X1
X$10242 \$19387 \$19483 \$19423 VDD VSS \$19444 HA_X1
X$10243 \$19444 \$19423 \$19389 VSS \$19388 VDD AOI21_X1
X$10245 dxin[3] VSS VDD \$2037 BUF_X1
X$10247 \$1641 VSS VDD \$1863 CLKBUF_X1
X$10248 \$2038 VSS VDD \$2572 CLKBUF_X1
X$10249 \$1862 VSS VDD \$1913 CLKBUF_X1
X$10250 \$2194 VSS VDD \$1862 CLKBUF_X1
X$10251 \$2095 VSS VDD \$2101 CLKBUF_X1
X$10252 \$1693 VSS VDD \$1594 CLKBUF_X1
X$10253 \$1865 VSS VDD \$2095 CLKBUF_X1
X$10254 VSS \$1593 \$I100205 \$2109 \$2101 \$1304 VDD DFFR_X1
X$10260 VSS \$1593 \$I99924 \$2194 \$2037 \$1304 VDD DFFR_X1
X$10265 \$2195 VSS VDD \$2335 CLKBUF_X1
X$10266 \$2243 VSS VDD \$2196 CLKBUF_X1
X$10267 \$2109 VSS VDD \$2103 CLKBUF_X1
X$10268 \$2105 VSS VDD \$2243 CLKBUF_X1
X$10269 \$2196 VSS VDD \$2249 CLKBUF_X1
X$10270 VSS \$1696 \$I99839 \$2484 \$1866 \$1304 VDD DFFR_X1
X$10271 VSS \$1696 \$I100380 \$2127 \$2113 \$1304 VDD DFFR_X1
X$10272 \$2111 VSS VDD \$1920 CLKBUF_X1
X$10275 \$2387 VSS VDD \$2391 CLKBUF_X1
X$10276 VSS \$1696 \$I99872 \$2198 \$1775 \$1304 VDD DFFR_X1
X$10277 \$2123 VSS VDD \$2120 CLKBUF_X1
X$10278 \$2258 VSS VDD \$2257 CLKBUF_X1
X$10279 \$2130 VSS VDD \$2042 CLKBUF_X1
X$10280 \$2198 VSS VDD \$2123 CLKBUF_X1
X$10281 \$2127 VSS VDD \$1934 CLKBUF_X1
X$10282 \$2121 VSS VDD \$1939 CLKBUF_X1
X$10287 \$2257 VSS VDD \$2130 CLKBUF_X1
X$10288 \$2120 VSS VDD \$2258 CLKBUF_X1
X$10289 \$2199 VSS VDD \$2339 CLKBUF_X1
X$10291 \$2266 VSS VDD \$2340 CLKBUF_X1
X$10297 \$1598 \$1869 \$2200 \$2647 VSS VDD \$2269 NAND4_X1
X$10298 \$1598 \$1869 \$2581 VSS VDD \$1795 NAND3_X1
X$10299 \$2269 \$2134 \$1868 VDD \$964 VSS OAI21_X1
X$10303 \$1962 VSS VDD \$1952 INV_X1
X$10306 \$2139 VSS VDD \$2138 INV_X1
X$10309 \$2143 \$1961 \$2045 VDD VSS \$2046 HA_X1
X$10312 \$293 \$25 VSS VDD \$2143 NOR2_X1
X$10313 \$197 \$428 VSS VDD \$1961 NOR2_X1
X$10317 \$1872 \$527 VSS VDD \$1967 NOR2_X1
X$10319 \$1871 \$1977 \$2139 VDD VSS \$1964 HA_X1
X$10322 \$2050 \$1161 VSS VDD \$1980 NOR2_X1
X$10323 \$2298 \$1980 \$1977 VDD VSS \$1710 HA_X1
X$10324 \$1488 \$2344 \$1486 \$2052 VSS VDD \$1603 NAND4_X1
X$10330 \$2274 \$2276 \$2200 VDD VSS \$2500 HA_X1
X$10333 \$2273 VSS VDD \$2274 INV_X1
X$10334 VSS \$2279 \$2273 \$2502 \$1952 \$2399 VDD FA_X1
X$10336 \$2137 VSS VDD \$2276 INV_X1
X$10339 VSS \$2400 \$2279 \$2505 \$2138 \$2202 VDD FA_X1
X$10340 \$2281 VSS VDD \$2202 INV_X1
X$10341 \$2283 VSS VDD \$2399 INV_X1
X$10344 VSS \$1344 \$2283 \$2281 \$2342 \$2046 VDD FA_X1
X$10347 \$197 \$25 VSS VDD \$2407 NOR2_X1
X$10353 \$1707 VSS VDD \$1690 CLKBUF_X1
X$10354 \$1161 VSS VDD \$1272 CLKBUF_X1
X$10357 \$2454 \$1707 VSS VDD \$2298 NOR2_X1
X$10361 \$20 VSS VDD \$2344 INV_X1
X$10362 VSS \$2313 \$1872 \$922 \$2315 \$45 VDD DFFR_X1
X$10363 \$1681 VSS VDD \$1993 CLKBUF_X1
X$10364 \$1875 VSS VDD \$2205 CLKBUF_X1
X$10367 VSS \$2313 \$I100059 \$2709 \$2208 \$45 VDD DFFR_X1
X$10368 \$2053 VSS VDD \$2209 CLKBUF_X1
X$10372 \$2054 VSS VDD \$2210 CLKBUF_X1
X$10373 \$1070 VSS VDD \$1876 CLKBUF_X1
X$10376 \$1606 VSS VDD \$1877 CLKBUF_X1
X$10378 \$1608 VSS VDD \$2000 CLKBUF_X1
X$10379 \$1609 VSS VDD \$1846 CLKBUF_X1
X$10382 VSS \$2171 \$1878 \$2170 \$1880 \$1879 VDD FA_X1
X$10384 VSS \$2178 \$2171 \$2015 \$1325 \$2055 VDD FA_X1
X$10385 \$2176 VSS VDD \$2055 INV_X1
X$10387 \$2211 VSS VDD \$2461 CLKBUF_X1
X$10389 VSS \$2347 \$I99985 \$2462 \$2318 \$45 VDD DFFR_X1
X$10393 \$2170 VSS VDD \$2349 INV_X1
X$10398 \$1881 VSS VDD \$2442 CLKBUF_X1
X$10401 \$1356 VSS VDD \$2179 CLKBUF_X1
X$10403 \$2327 VSS VDD \$2439 CLKBUF_X1
X$10406 VSS \$2189 \$2178 \$2558 \$2034 \$1883 VDD FA_X1
X$10410 \$2333 VSS VDD \$2189 INV_X1
X$10411 VSS \$2212 \$2333 \$2719 \$2553 \$2350 VDD FA_X1
X$10413 \$2057 \$940 VSS VDD \$2028 NAND2_X1
X$10414 \$726 \$1494 VSS VDD \$2463 NAND2_X1
X$10417 \$2058 \$2184 VSS VDD \$1844 NOR2_X1
X$10418 \$1171 VSS VDD \$2058 INV_X1
X$10419 \$727 \$2184 VSS VDD \$2326 NAND2_X1
X$10421 \$2326 VSS VDD \$2212 INV_X1
X$10422 \$2322 VSS VDD \$1579 CLKBUF_X1
X$10423 VSS \$2215 \$I100022 \$2546 \$2712 \$327 VDD DFFR_X1
X$10424 \$2183 VSS VDD \$2025 CLKBUF_X1
X$10428 \$2356 VSS VDD \$1574 CLKBUF_X1
X$10430 \$2360 VSS VDD \$1318 CLKBUF_X1
X$10434 VSS \$2215 \$I99861 \$2355 \$2319 \$327 VDD DFFR_X1
X$10437 \$2355 \$1889 VSS VDD \$1496 NOR2_X1
X$10438 \$2061 VSS VDD \$1618 INV_X1
X$10439 \$2064 VSS VDD \$2016 CLKBUF_X1
X$10440 \$2061 \$2062 VSS VDD \$2063 NAND2_X1
X$10441 \$2063 \$1989 \$1890 VDD \$1368 VSS OAI21_X1
X$10442 \$2161 \$1618 \$1369 VDD \$2009 VSS OAI21_X1
X$10443 \$1618 VSS VDD \$2011 CLKBUF_X1
X$10444 \$2009 VSS VDD \$1890 INV_X1
X$10446 \$1892 \$2003 \$2161 VDD \$1721 VSS OAI21_X1
X$10447 \$2062 VSS VDD \$1892 INV_X1
X$10449 \$2158 \$2070 VSS VDD \$1893 NAND2_X1
X$10453 \$397 \$395 \$1889 VDD VSS \$2184 AND3_X1
X$10454 \$1989 \$2062 VDD VSS \$2357 XNOR2_X1
X$10455 \$2358 VSS VDD \$1369 INV_X1
X$10456 \$2158 VSS VDD \$2062 CLKBUF_X1
X$10459 \$2305 VSS VDD \$2161 INV_X1
X$10461 VSS \$1727 \$I99864 \$2363 \$2301 \$327 VDD DFFR_X1
X$10462 \$2068 \$2070 \$2156 VSS \$2003 VDD AOI21_X1
X$10464 \$2068 VSS VDD \$1994 INV_X1
X$10467 \$2292 VSS VDD \$1724 INV_X1
X$10470 \$2069 \$1994 \$1895 VSS VDD \$1991 NAND3_X1
X$10471 \$2070 \$2071 \$2146 VSS VDD \$1895 NAND3_X1
X$10472 \$1991 \$2072 \$946 VSS \$1989 VDD AOI21_X1
X$10474 \$1896 \$1897 \$2073 VDD \$2146 VSS OAI21_X1
X$10475 \$1897 \$2075 \$2073 VDD \$2074 VSS OAI21_X1
X$10482 \$2156 \$2222 VDD VSS \$2364 XNOR2_X1
X$10484 \$2404 VSS VDD \$2222 INV_X1
X$10486 \$2222 \$2223 \$1894 VSS VDD \$2072 NOR3_X1
X$10488 \$2073 \$2223 \$2366 VDD \$2292 VSS OAI21_X1
X$10490 \$2224 VSS VDD \$2223 INV_X1
X$10492 \$2074 \$2223 VDD VSS \$2395 XNOR2_X1
X$10496 \$2230 \$2076 VSS VDD \$2226 NAND2_X1
X$10497 \$2076 \$2078 VSS VDD \$2079 NAND2_X1
X$10500 \$2079 VSS VDD \$1730 INV_X1
X$10504 \$2122 VSS VDD \$1956 INV_X1
X$10506 \$2226 \$1816 \$2227 \$1968 VSS VDD \$2277 NAND4_X1
X$10507 \$2230 \$2078 \$2229 VSS \$2468 VDD AOI21_X1
X$10511 \$2265 \$2369 \$2078 VDD VSS \$2230 HA_X1
X$10514 \$2390 VSS VDD \$2265 INV_X1
X$10516 \$2081 \$2255 \$1376 VDD VSS \$1899 HA_X1
X$10517 \$2119 VSS VDD \$1957 INV_X1
X$10521 \$2256 VSS VDD \$2255 INV_X1
X$10522 \$2371 \$2084 VSS VDD \$2256 NAND2_X1
X$10523 \$2231 VSS VDD \$2081 INV_X1
X$10525 \$1904 \$1901 VSS VDD \$2082 NAND2_X1
X$10527 \$2082 VSS VDD \$1900 INV_X1
X$10530 \$1739 \$2251 VSS VDD \$2247 NAND2_X1
X$10531 \$2247 VSS VDD \$1937 INV_X1
X$10537 \$2083 \$2371 VSS VDD \$1921 NAND2_X1
X$10539 \$2084 \$1904 VSS VDD \$1903 NAND2_X1
X$10543 \$2084 \$1902 VSS VDD \$1905 NAND2_X1
X$10544 \$2084 \$1735 VSS VDD \$2102 NAND2_X1
X$10545 \$2083 \$1904 VSS VDD \$1916 NAND2_X1
X$10546 \$2102 VSS VDD \$1907 INV_X1
X$10549 \$1907 \$1739 \$2083 VDD VSS \$1909 AND3_X1
X$10550 \$2092 \$1901 \$2091 VDD VSS \$1378 AND3_X1
X$10562 \$2233 VSS VDD \$1745 INV_X1
X$10564 \$2083 \$1902 VSS VDD \$2233 NAND2_X1
X$10580 dxin[5] VSS VDD \$7551 BUF_X1
X$10582 \$7637 VSS VDD \$6993 CLKBUF_X1
X$10583 \$7390 VSS VDD \$7637 CLKBUF_X1
X$10584 VSS \$7552 \$I100491 \$6926 \$7307 \$3006 VDD DFFR_X1
X$10586 \$7898 VSS VDD \$7813 CLKBUF_X1
X$10588 \$7649 VSS VDD \$7650 CLKBUF_X1
X$10589 \$7650 VSS VDD \$7408 CLKBUF_X1
X$10590 \$7655 VSS VDD \$7311 CLKBUF_X1
X$10591 VSS \$7556 \$I100312 \$7657 \$7311 \$3006 VDD DFFR_X1
X$10592 \$7657 VSS VDD \$7659 CLKBUF_X1
X$10593 \$7659 VSS VDD \$7907 CLKBUF_X1
X$10594 \$7410 VSS VDD \$7417 CLKBUF_X1
X$10595 \$7408 VSS VDD \$7405 CLKBUF_X1
X$10598 \$2886 VSS VDD \$6180 CLKBUF_X3
X$10599 VSS \$6340 \$I100221 \$7563 \$7665 \$3006 VDD DFFR_X1
X$10603 VSS \$7552 \$I100019 \$7160 \$7551 \$3006 VDD DFFR_X1
X$10607 VSS \$7556 \$I100062 \$7310 \$7308 \$3006 VDD DFFR_X1
X$10609 VSS \$7556 \$I100055 \$7815 \$7560 \$3006 VDD DFFR_X1
X$10610 VSS \$7556 \$I100105 \$7818 \$279 \$3006 VDD DFFR_X1
X$10613 VSS \$6340 \$I100077 \$7922 \$7916 \$3006 VDD DFFR_X1
X$10615 \$7921 VSS VDD \$7820 CLKBUF_X1
X$10616 \$7924 VSS VDD \$7926 CLKBUF_X1
X$10617 \$7926 VSS VDD \$7665 CLKBUF_X1
X$10618 \$7923 VSS VDD \$7924 CLKBUF_X1
X$10620 \$7928 VSS VDD \$7313 CLKBUF_X1
X$10621 \$7563 VSS VDD \$7676 CLKBUF_X1
X$10622 \$7678 VSS VDD \$7928 CLKBUF_X1
X$10623 \$7676 VSS VDD \$7678 CLKBUF_X1
X$10624 \$7313 VSS VDD \$7314 CLKBUF_X1
X$10625 \$7314 VSS VDD \$7425 CLKBUF_X1
X$10627 \$7316 VSS VDD \$7315 CLKBUF_X1
X$10628 \$7680 VSS VDD \$7167 CLKBUF_X1
X$10629 \$7166 VSS VDD \$7929 CLKBUF_X1
X$10631 VSS \$7564 \$I100267 \$7821 \$7317 \$6364 VDD DFFR_X1
X$10632 \$7170 VSS VDD \$7433 CLKBUF_X1
X$10633 \$7321 \$7433 VDD VSS \$7436 XNOR2_X1
X$10634 \$7827 VSS VDD \$7696 CLKBUF_X1
X$10635 \$6940 \$7692 \$7566 VDD VSS \$7572 HA_X1
X$10637 \$7700 \$7704 VSS VDD \$7573 NAND2_X1
X$10638 \$7322 VSS VDD \$7703 CLKBUF_X1
X$10639 \$7703 VSS VDD \$7441 CLKBUF_X1
X$10640 \$7573 \$7567 \$7450 VSS VDD \$7321 NAND3_X1
X$10641 \$7704 \$7833 \$7574 VSS VDD \$7450 NAND3_X1
X$10642 \$7323 \$7709 \$7965 VDD VSS \$7700 HA_X1
X$10644 \$7458 VSS VDD \$7575 CLKBUF_X1
X$10645 \$7324 VSS VDD \$7717 CLKBUF_X1
X$10646 \$7717 VSS VDD \$7716 CLKBUF_X1
X$10647 \$7716 VSS VDD \$7459 CLKBUF_X1
X$10648 \$7719 VSS VDD \$7462 CLKBUF_X1
X$10649 \$7325 VSS VDD \$7719 CLKBUF_X1
X$10654 \$7929 VSS VDD \$7680 CLKBUF_X1
X$10657 \$7683 VSS VDD \$7930 CLKBUF_X1
X$10660 \$7436 VSS VDD \$7565 CLKBUF_X1
X$10661 VSS \$7564 \$I99958 \$7945 \$7565 \$6364 VDD DFFR_X1
X$10662 \$7567 \$7170 \$7829 \$7938 \$7953 VDD VSS \$8121 OAI221_X1
X$10663 \$7696 VSS VDD \$7570 CLKBUF_X1
X$10664 \$7566 VSS VDD \$6939 CLKBUF_X1
X$10665 \$7572 VSS VDD \$7829 INV_X1
X$10668 \$6077 \$7960 \$7704 VDD VSS \$7966 HA_X1
X$10669 \$7965 VSS VDD \$7833 CLKBUF_X1
X$10670 \$7834 VSS VDD \$7709 INV_X1
X$10671 \$7966 VSS VDD \$7567 INV_X1
X$10673 \$7574 VSS VDD \$7835 INV_X1
X$10675 \$7575 VSS VDD \$7836 CLKBUF_X1
X$10679 \$7576 \$7970 \$7838 VDD VSS \$7574 HA_X1
X$10681 \$7172 VSS VDD \$7576 CLKBUF_X1
X$10684 VSS \$7578 \$I100363 \$7730 \$7329 \$6364 VDD DFFR_X1
X$10685 VSS \$7578 \$I100239 \$7327 \$6748 \$6364 VDD DFFR_X1
X$10686 VSS \$6883 \$I100445 \$7333 \$7843 \$6364 VDD DFFR_X1
X$10687 \$5493 VSS VDD \$6883 CLKBUF_X3
X$10688 \$7490 VSS VDD \$7580 CLKBUF_X1
X$10689 \$7486 VSS VDD \$7490 CLKBUF_X1
X$10690 \$7747 VSS VDD \$8004 CLKBUF_X1
X$10691 \$7497 VSS VDD \$7493 CLKBUF_X1
X$10692 VSS \$6883 \$I100452 \$7752 \$7581 \$6364 VDD DFFR_X1
X$10693 \$7506 VSS VDD \$7507 CLKBUF_X1
X$10694 VSS \$6755 \$I100471 \$7765 \$7759 \$6364 VDD DFFR_X1
X$10695 \$7763 VSS VDD \$7766 CLKBUF_X1
X$10698 \$7326 VSS VDD \$7577 CLKBUF_X1
X$10700 \$7726 VSS VDD \$7981 CLKBUF_X1
X$10701 \$7327 VSS VDD \$7976 CLKBUF_X1
X$10702 \$7979 VSS VDD \$7329 CLKBUF_X1
X$10703 \$7840 VSS VDD \$7726 CLKBUF_X1
X$10704 \$7981 VSS VDD \$7979 CLKBUF_X1
X$10705 \$7980 VSS VDD \$7985 CLKBUF_X1
X$10706 \$7730 VSS VDD \$7841 CLKBUF_X1
X$10707 \$7986 VSS VDD \$7980 CLKBUF_X1
X$10708 VSS \$7578 \$I99999 \$7992 \$6493 \$6364 VDD DFFR_X1
X$10709 VSS \$6883 \$I100096 \$7846 \$8001 \$6364 VDD DFFR_X1
X$10715 \$7845 VSS VDD \$7581 CLKBUF_X1
X$10716 \$8004 VSS VDD \$7845 CLKBUF_X1
X$10719 \$7752 VSS VDD \$7758 CLKBUF_X1
X$10720 \$7756 VSS VDD \$7847 CLKBUF_X1
X$10721 \$8012 VSS VDD \$7756 CLKBUF_X1
X$10722 \$7847 VSS VDD \$8009 CLKBUF_X1
X$10723 \$7758 VSS VDD \$8012 CLKBUF_X1
X$10724 \$8017 VSS VDD \$7759 CLKBUF_X1
X$10726 \$7765 VSS VDD \$7763 CLKBUF_X1
X$10727 VSS \$7582 \$I100128 \$8532 \$6359 \$6364 VDD DFFR_X1
X$10728 \$7337 VSS VDD \$7336 CLKBUF_X1
X$10733 \$6754 VSS VDD \$7584 CLKBUF_X1
X$10735 \$7339 VSS VDD \$7777 CLKBUF_X1
X$10736 \$7777 VSS VDD \$7586 CLKBUF_X1
X$10737 \$6755 VSS VDD \$I93892 CLKBUF_X1
X$10741 \$8035 VSS VDD \$8031 CLKBUF_X1
X$10742 \$7586 VSS VDD \$8035 CLKBUF_X1
X$10743 \$8029 VSS VDD \$7788 CLKBUF_X1
X$10746 \$8045 VSS VDD \$7587 CLKBUF_X1
X$10747 \$7534 VSS VDD \$7781 CLKBUF_X1
X$10749 \$7781 VSS VDD \$7531 CLKBUF_X1
X$10750 VSS \$7589 \$I100198 \$7785 \$7343 \$6364 VDD DFFR_X1
X$10752 \$7790 VSS VDD \$7792 CLKBUF_X1
X$10753 VSS \$7589 \$I100510 \$7799 \$7346 \$6364 VDD DFFR_X1
X$10755 \$7799 VSS VDD \$7797 CLKBUF_X1
X$10756 VSS \$7594 \$I100195 \$8088 \$7348 \$6763 VDD DFFR_X1
X$10758 \$7588 VSS VDD \$7591 CLKBUF_X1
X$10759 \$7590 VSS VDD \$8045 CLKBUF_X1
X$10760 \$8047 VSS VDD \$7343 CLKBUF_X1
X$10761 \$7344 VSS VDD \$8047 CLKBUF_X1
X$10762 \$7785 VSS VDD \$8069 CLKBUF_X1
X$10763 \$8054 VSS VDD \$7850 CLKBUF_X1
X$10764 \$7592 VSS VDD \$8054 CLKBUF_X1
X$10765 \$7788 VSS VDD \$8063 CLKBUF_X1
X$10766 \$8294 VSS VDD \$8062 CLKBUF_X1
X$10767 \$8299 VSS VDD \$8131 CLKBUF_X1
X$10769 \$7792 VSS VDD \$7346 CLKBUF_X1
X$10770 \$8070 VSS VDD \$7790 CLKBUF_X1
X$10771 \$8069 VSS VDD \$8070 CLKBUF_X1
X$10774 \$7797 VSS VDD \$7853 CLKBUF_X1
X$10775 \$8077 VSS VDD \$7803 CLKBUF_X1
X$10776 \$7853 VSS VDD \$8077 CLKBUF_X1
X$10777 \$8081 VSS VDD \$7348 CLKBUF_X1
X$10778 \$7803 VSS VDD \$8081 CLKBUF_X1
X$10779 \$8088 VSS VDD \$7802 CLKBUF_X1
X$10780 \$7806 VSS VDD \$7800 CLKBUF_X1
X$10781 \$8317 VSS VDD \$8585 CLKBUF_X1
X$10782 \$7855 VSS VDD \$7856 CLKBUF_X1
X$10783 \$8090 VSS VDD \$8092 CLKBUF_X1
X$10784 VSS \$7594 \$I100084 \$8102 \$8095 \$6763 VDD DFFR_X1
X$10785 \$7800 VSS VDD \$7351 CLKBUF_X1
X$10786 \$7351 VSS VDD \$8095 CLKBUF_X1
X$10787 \$7539 VSS VDD \$7806 CLKBUF_X1
X$10788 \$7805 VSS VDD \$7538 CLKBUF_X1
X$10790 \$7533 VSS VDD \$7597 CLKBUF_X1
X$10791 \$7189 VSS VDD \$I93964 CLKBUF_X1
X$10792 \$7598 VSS VDD \$6960 CLKBUF_X1
X$10793 \$7353 VSS VDD \$7529 CLKBUF_X1
X$10794 \$5666 VSS VDD \$7189 CLKBUF_X3
X$10795 \$7529 VSS VDD \$7528 CLKBUF_X1
X$10799 VSS \$7189 \$I100486 \$7603 \$7602 \$6763 VDD DFFR_X1
X$10800 VSS \$7193 \$I100229 \$7516 \$7604 \$6763 VDD DFFR_X1
X$10801 VSS \$7193 \$I100271 \$7194 \$7770 \$4734 VDD DFFR_X1
X$10803 \$5666 VSS VDD \$7193 CLKBUF_X3
X$10804 \$7608 VSS VDD \$7494 CLKBUF_X1
X$10805 VSS \$7609 \$I100539 \$7748 \$7741 \$4734 VDD DFFR_X1
X$10806 \$7748 VSS VDD \$7358 CLKBUF_X1
X$10807 \$7612 VSS VDD \$7483 CLKBUF_X1
X$10808 \$7358 VSS VDD \$7612 CLKBUF_X1
X$10809 VSS \$7609 \$I100308 \$7614 \$7728 \$4734 VDD DFFR_X1
X$10810 \$7615 VSS VDD \$7616 CLKBUF_X1
X$10811 \$7361 VSS VDD \$7362 CLKBUF_X1
X$10812 \$7617 VSS VDD \$7361 CLKBUF_X1
X$10813 \$7362 VSS VDD \$7467 CLKBUF_X1
X$10814 \$7461 VSS VDD \$7720 CLKBUF_X1
X$10815 \$7363 VSS VDD \$7461 CLKBUF_X1
X$10816 VSS \$7618 \$I100326 \$4380 \$7718 \$4734 VDD DFFR_X1
X$10817 \$7720 VSS VDD \$6975 CLKBUF_X1
X$10818 \$7876 VSS VDD \$8487 CLKBUF_X1
X$10819 \$8218 VSS VDD \$7254 CLKBUF_X1
X$10820 \$7445 VSS VDD \$7255 CLKBUF_X1
X$10821 \$6976 VSS VDD \$7447 CLKBUF_X1
X$10822 \$7710 VSS VDD \$7707 CLKBUF_X1
X$10823 \$7707 VSS VDD \$7442 CLKBUF_X1
X$10825 \$7698 VSS VDD \$7366 CLKBUF_X1
X$10826 \$7365 VSS VDD \$7621 CLKBUF_X1
X$10827 \$7366 VSS VDD \$6772 CLKBUF_X1
X$10828 \$7621 VSS VDD \$7695 CLKBUF_X1
X$10829 \$7695 VSS VDD \$7367 CLKBUF_X1
X$10831 \$7368 VSS VDD \$7369 CLKBUF_X1
X$10832 \$7689 VSS VDD \$5938 CLKBUF_X1
X$10835 \$7596 VSS VDD \$7859 CLKBUF_X1
X$10836 \$7860 VSS VDD \$8097 CLKBUF_X1
X$10837 \$8102 VSS VDD \$7860 CLKBUF_X1
X$10838 \$7597 VSS VDD \$7598 CLKBUF_X1
X$10842 \$8293 VSS VDD \$7602 CLKBUF_X1
X$10844 \$7521 VSS VDD \$8112 CLKBUF_X1
X$10845 \$8112 VSS VDD \$7776 CLKBUF_X1
X$10846 \$7603 VSS VDD \$7356 CLKBUF_X1
X$10847 \$8104 VSS VDD \$7604 CLKBUF_X1
X$10848 \$8108 VSS VDD \$8100 CLKBUF_X1
X$10850 VSS \$8146 \$I100130 \$8093 \$7605 \$4734 VDD DFFR_X1
X$10851 \$8086 VSS VDD \$7864 CLKBUF_X1
X$10852 \$7607 VSS VDD \$7863 CLKBUF_X1
X$10853 \$7864 VSS VDD \$7770 CLKBUF_X1
X$10854 \$8079 VSS VDD \$7768 CLKBUF_X1
X$10855 \$8056 VSS VDD \$7608 CLKBUF_X1
X$10859 \$7862 VSS VDD \$7742 CLKBUF_X1
X$10860 \$8059 VSS VDD \$8071 CLKBUF_X1
X$10862 \$8052 VSS VDD \$8534 CLKBUF_X1
X$10864 \$8053 VSS VDD \$8058 CLKBUF_X1
X$10866 \$7610 VSS VDD \$8049 CLKBUF_X1
X$10867 \$7743 VSS VDD \$7866 CLKBUF_X1
X$10868 \$8043 VSS VDD \$8521 CLKBUF_X1
X$10869 \$8049 VSS VDD \$7611 CLKBUF_X1
X$10870 \$7742 VSS VDD \$8014 CLKBUF_X1
X$10872 \$7727 VSS VDD \$7729 CLKBUF_X1
X$10873 \$8026 VSS VDD \$8028 CLKBUF_X1
X$10874 \$8028 VSS VDD \$7727 CLKBUF_X1
X$10875 \$7729 VSS VDD \$7728 CLKBUF_X1
X$10878 \$7614 VSS VDD \$7615 CLKBUF_X1
X$10879 \$7616 VSS VDD \$7617 CLKBUF_X1
X$10881 \$8239 VSS VDD \$8158 CLKBUF_X1
X$10882 VSS \$7618 \$I99901 \$7874 \$7993 \$6120 VDD DFFR_X1
X$10883 \$7620 VSS VDD \$7718 CLKBUF_X1
X$10885 VSS \$7875 \$I99940 \$7877 \$7969 \$6120 VDD DFFR_X1
X$10886 \$7877 VSS VDD \$7961 CLKBUF_X1
X$10887 \$8210 VSS VDD \$7958 CLKBUF_X1
X$10888 \$7961 VSS VDD \$7963 CLKBUF_X1
X$10890 \$7963 VSS VDD \$7964 CLKBUF_X1
X$10891 \$7964 VSS VDD \$7954 CLKBUF_X1
X$10893 \$7954 VSS VDD \$7622 CLKBUF_X1
X$10894 VSS \$7233 \$I99955 \$7941 \$7622 \$6120 VDD DFFR_X1
X$10896 \$7370 VSS VDD \$6774 CLKBUF_X1
X$10897 VSS \$7233 \$I100420 \$7624 \$7372 \$6120 VDD DFFR_X1
X$10898 \$7688 VSS VDD \$7689 CLKBUF_X1
X$10899 \$7375 VSS VDD \$7234 CLKBUF_X1
X$10900 \$7376 VSS VDD \$6377 CLKBUF_X1
X$10901 \$7674 VSS VDD \$7050 CLKBUF_X1
X$10902 \$7664 VSS VDD \$7625 CLKBUF_X1
X$10903 \$7626 VSS VDD \$7377 CLKBUF_X1
X$10904 \$7627 VSS VDD \$7626 CLKBUF_X1
X$10905 \$7378 VSS VDD \$7379 CLKBUF_X1
X$10906 \$7380 VSS VDD \$7229 CLKBUF_X1
X$10907 \$7651 VSS VDD \$7414 CLKBUF_X1
X$10908 \$7226 VSS VDD \$7654 CLKBUF_X1
X$10909 \$7654 VSS VDD \$7413 CLKBUF_X1
X$10911 \$6987 \$6379 VSS VDD \$7629 NAND2_X1
X$10912 \$7629 VSS VDD \$7407 INV_X1
X$10913 \$7648 VSS VDD \$7645 INV_X1
X$10914 \$7645 \$7407 \$7641 VDD VSS \$7643 HA_X1
X$10916 VSS \$7638 \$8182 \$7389 \$7400 \$7396 VDD FA_X1
X$10918 \$7641 VSS VDD \$7635 INV_X1
X$10920 \$7941 VSS VDD \$7937 CLKBUF_X1
X$10921 \$7685 VSS VDD \$7682 CLKBUF_X1
X$10922 \$7881 VSS VDD \$7674 CLKBUF_X1
X$10923 \$7937 VSS VDD \$7685 CLKBUF_X1
X$10924 \$7884 VSS VDD \$7204 CLKBUF_X1
X$10925 \$7682 VSS VDD \$7884 CLKBUF_X1
X$10926 \$7624 VSS VDD \$7664 CLKBUF_X1
X$10927 \$7625 VSS VDD \$7627 CLKBUF_X1
X$10928 \$7377 VSS VDD \$7206 CLKBUF_X1
X$10931 \$7885 VSS VDD \$7651 CLKBUF_X1
X$10932 \$7379 VSS VDD \$7380 CLKBUF_X1
X$10933 \$7869 \$6986 VSS VDD \$7628 NAND2_X1
X$10934 \$7628 VSS VDD \$7900 INV_X1
X$10937 \$7877 \$6986 VSS VDD \$7648 NAND2_X1
X$10941 VSS \$7635 \$7894 \$7391 \$6989 \$7383 VDD FA_X1
X$10942 \$7385 \$7389 \$7384 VDD VSS \$7632 HA_X1
X$10952 \$7894 VSS VDD \$8403 INV_X1
X$10955 \$7890 VSS VDD \$7889 INV_X1
X$10966 dxin[1] VSS VDD \$1062 BUF_X1
X$10974 \$831 \$611 VDD VSS \$961 XNOR2_X1
X$10975 \$913 \$1063 \$1097 VSS \$831 VDD AOI21_X1
X$10979 VSS \$1339 \$I99927 \$1184 \$1062 \$1304 VDD DFFR_X1
X$10983 \$1301 VSS VDD \$1509 CLKBUF_X1
X$10984 \$1184 VSS VDD \$1389 CLKBUF_X1
X$10986 \$1186 VSS VDD \$1157 CLKBUF_X1
X$10987 \$1156 VSS VDD \$1186 CLKBUF_X1
X$10993 \$968 \$967 \$1063 VDD VSS \$913 HA_X1
X$10995 \$1102 VSS VDD \$968 INV_X1
X$11000 \$1193 VSS VDD \$1269 INV_X1
X$11002 VSS \$1104 \$1102 \$1193 \$751 \$914 VDD FA_X1
X$11004 VSS \$1122 \$1104 \$1158 \$715 \$980 VDD FA_X1
X$11006 \$1109 VSS VDD \$980 INV_X1
X$11009 \$436 VSS VDD \$1406 INV_X1
X$11012 \$1198 VSS VDD \$1270 INV_X1
X$11016 VSS \$1199 \$1198 \$1271 \$33 \$917 VDD FA_X1
X$11017 \$916 \$917 \$436 VDD VSS \$437 HA_X1
X$11019 \$578 \$428 VSS VDD \$916 NOR2_X1
X$11020 \$578 \$25 VSS VDD \$917 NOR2_X1
X$11023 \$1209 \$33 VSS VDD \$920 NAND2_X1
X$11025 \$169 \$428 VSS VDD \$1199 NOR2_X1
X$11028 \$1160 VSS VDD \$1209 INV_X1
X$11031 VSS \$1329 \$1122 \$1066 \$1125 \$994 VDD FA_X1
X$11032 \$1002 \$1161 VSS VDD \$131 NOR2_X1
X$11033 VSS \$1135 \$984 \$994 \$1133 \$926 VDD FA_X1
X$11034 \$1068 \$584 VSS VDD \$1135 NAND2_X1
X$11036 VSS \$589 \$1009 \$386 \$1015 \$45 VDD DFFR_X1
X$11037 \$191 VSS VDD \$589 CLKBUF_X3
X$11039 \$1152 VSS VDD \$1015 CLKBUF_X1
X$11041 \$389 VSS VDD \$1070 CLKBUF_X1
X$11052 \$1272 VSS VDD \$43 INV_X1
X$11053 \$1160 \$43 VSS VDD \$1425 NAND2_X1
X$11054 \$922 \$153 VSS VDD \$1273 NAND2_X1
X$11057 VSS \$589 \$I99903 \$1274 \$153 \$45 VDD DFFR_X1
X$11059 \$1230 VSS VDD \$1441 CLKBUF_X1
X$11060 \$1334 VSS VDD \$1011 CLKBUF_X1
X$11061 \$1233 VSS VDD \$1234 CLKBUF_X1
X$11062 VSS \$589 \$I99804 \$1332 \$1234 \$45 VDD DFFR_X1
X$11063 \$1165 VSS VDD \$1152 CLKBUF_X1
X$11065 \$1240 VSS VDD \$1165 CLKBUF_X1
X$11066 \$931 VSS VDD \$1071 CLKBUF_X1
X$11070 VSS \$720 \$I100287 \$1154 \$1153 \$85 VDD DFFR_X1
X$11072 \$1073 VSS VDD \$1153 CLKBUF_X1
X$11074 \$1048 \$936 VSS VDD \$838 NAND2_X1
X$11075 \$1255 \$1149 VSS VDD \$936 NAND2_X1
X$11076 \$1147 \$1255 \$1149 VSS VDD \$937 NAND3_X1
X$11077 \$1048 VSS VDD \$1147 INV_X1
X$11080 \$1248 VSS VDD \$1262 CLKBUF_X1
X$11081 VSS \$725 \$I100521 \$1144 \$1244 \$85 VDD DFFR_X1
X$11083 \$725 VSS VDD \$I69239 INV_X1
X$11084 \$726 \$458 VSS VDD \$1239 NAND2_X1
X$11085 \$1130 VSS VDD \$725 CLKBUF_X3
X$11086 \$727 \$940 VSS VDD \$1078 NAND2_X1
X$11092 \$1243 VSS VDD \$1240 CLKBUF_X1
X$11095 \$1166 VSS VDD \$1243 CLKBUF_X1
X$11097 \$720 VSS VDD \$I68579 INV_X1
X$11098 \$1154 VSS VDD \$1166 CLKBUF_X1
X$11099 \$1277 \$1167 VDD VSS \$1168 XNOR2_X1
X$11100 \$1168 \$1459 VDD VSS \$836 XNOR2_X1
X$11102 \$1278 \$1279 VSS VDD \$1149 NAND2_X1
X$11103 \$1256 VSS VDD \$1073 CLKBUF_X1
X$11104 \$722 VSS VDD \$1881 CLKBUF_X1
X$11106 \$1262 VSS VDD \$1256 CLKBUF_X1
X$11107 \$702 VSS VDD \$1356 CLKBUF_X1
X$11108 VSS \$1237 \$1048 \$1281 \$1279 \$1253 VDD FA_X1
X$11109 \$1169 VSS VDD \$723 CLKBUF_X1
X$11110 \$1245 VSS VDD \$1248 CLKBUF_X1
X$11112 \$1144 VSS VDD \$1245 CLKBUF_X1
X$11113 \$726 \$940 VSS VDD \$1282 NAND2_X1
X$11116 VSS \$1236 \$1284 \$1237 \$1239 \$1078 VDD FA_X1
X$11119 \$1171 \$1172 VSS VDD \$1236 NAND2_X1
X$11120 \$1172 VSS VDD \$1321 INV_X1
X$11122 \$1318 VSS VDD \$1047 CLKBUF_X1
X$11124 \$393 \$940 \$1080 VDD VSS \$1082 HA_X1
X$11128 \$1082 \$1080 \$1081 VSS \$398 VDD AOI21_X1
X$11131 \$393 \$1321 \$1173 VDD VSS \$1229 HA_X1
X$11134 \$1173 VSS VDD \$1175 INV_X1
X$11135 \$1229 VSS VDD \$1176 INV_X1
X$11136 \$1175 \$1447 \$1176 VDD \$1081 VSS OAI21_X1
X$11138 \$1082 VSS VDD \$1036 INV_X1
X$11139 \$1080 \$1173 VSS VDD \$1177 NAND2_X1
X$11141 \$1080 VSS VDD \$941 INV_X1
X$11146 \$1176 \$941 \$1036 \$1177 \$1178 VDD VSS \$1316 OAI221_X1
X$11147 \$1216 VSS VDD \$1178 INV_X1
X$11154 \$1130 VSS VDD \$464 CLKBUF_X3
X$11158 \$945 VSS VDD \$1021 CLKBUF_X1
X$11164 \$1214 VSS VDD \$845 INV_X1
X$11166 \$944 \$848 VSS VDD \$1084 NAND2_X1
X$11167 \$845 VSS VDD \$943 CLKBUF_X1
X$11170 \$847 VSS VDD \$1214 CLKBUF_X1
X$11171 \$1121 VSS VDD \$944 INV_X1
X$11172 \$1207 \$844 \$847 VDD VSS \$1121 HA_X1
X$11179 \$15579 \$14884 \$12651 VSS VDD \$15756 NAND3_X1
X$11180 \$15756 VSS VDD \$15737 INV_X1
X$11183 \$15580 \$15744 VSS VDD \$15733 NAND2_X1
X$11184 \$15737 \$15749 \$15580 VDD VSS \$15736 HA_X1
X$11185 \$15736 VSS VDD \$15734 INV_X1
X$11187 \$15734 \$15733 VSS VDD \$16510 NAND2_X1
X$11195 \$14884 \$13033 VSS VDD \$15731 NAND2_X1
X$11196 \$15731 VSS VDD \$15979 INV_X1
X$11197 \$15747 \$15979 \$15743 VDD VSS \$15965 HA_X1
X$11199 \$15743 \$15968 \$15749 VDD VSS \$16514 HA_X1
X$11215 \$8113 VSS VDD \$8320 CLKBUF_X1
X$11216 \$8321 VSS VDD \$8674 CLKBUF_X1
X$11217 \$8406 VSS VDD \$8409 CLKBUF_X1
X$11218 \$8674 VSS VDD \$8405 CLKBUF_X1
X$11219 \$8593 VSS VDD \$8323 CLKBUF_X1
X$11220 VSS \$7552 \$I100490 \$8595 \$8323 \$3006 VDD DFFR_X1
X$11221 \$8683 VSS VDD \$8686 CLKBUF_X1
X$11222 \$8596 VSS VDD \$8683 CLKBUF_X1
X$11223 \$8423 VSS VDD \$8687 CLKBUF_X1
X$11224 \$8689 VSS VDD \$7898 CLKBUF_X1
X$11225 \$8116 VSS VDD \$7560 CLKBUF_X1
X$11226 \$8686 VSS VDD \$8689 CLKBUF_X1
X$11229 \$8696 VSS VDD \$8326 CLKBUF_X1
X$11230 \$8327 VSS VDD \$8325 CLKBUF_X1
X$11232 \$7818 VSS VDD \$8328 CLKBUF_X1
X$11233 \$8330 VSS VDD \$8696 CLKBUF_X1
X$11234 \$8438 VSS VDD \$8699 CLKBUF_X1
X$11235 \$8701 VSS VDD \$8438 CLKBUF_X1
X$11240 \$7552 VSS VDD \$I68577 INV_X1
X$11241 VSS \$7552 \$I100008 \$8870 \$9093 \$3006 VDD DFFR_X1
X$11245 VSS \$7556 \$I100005 \$8874 \$8871 \$3006 VDD DFFR_X1
X$11246 \$8595 VSS VDD \$8596 CLKBUF_X1
X$11248 \$8875 VDD \$3006 VSS BUF_X4
X$11251 \$9332 VSS VDD \$9420 CLKBUF_X1
X$11252 \$9184 VSS VDD \$8876 CLKBUF_X1
X$11253 VSS \$9099 \$I99978 \$8701 \$8325 \$8875 VDD DFFR_X1
X$11254 \$9192 VSS VDD \$8960 INV_X1
X$11255 \$8960 \$8709 \$8878 VDD \$9100 VSS OAI21_X1
X$11256 \$8599 \$8960 \$8878 \$8879 \$8881 VDD VSS \$9333 OAI221_X1
X$11258 \$8974 \$8119 VSS VDD \$8879 NAND2_X1
X$11260 \$8446 \$8444 \$8119 VDD VSS \$8600 HA_X1
X$11263 \$8457 VSS VDD \$8446 CLKBUF_X1
X$11264 \$8333 \$8599 \$8452 VSS VDD \$8718 NAND3_X1
X$11265 \$8119 \$8724 \$8721 VSS VDD \$8452 NAND3_X1
X$11266 \$8335 \$8605 \$8334 VDD \$8458 VSS OAI21_X1
X$11267 \$8724 VSS VDD \$8604 CLKBUF_X1
X$11268 \$8456 VSS VDD \$8334 INV_X1
X$11270 \$8476 \$8336 \$8335 VDD \$8721 VSS OAI21_X1
X$11271 \$8336 \$8738 \$8335 VDD \$8468 VSS OAI21_X1
X$11272 \$8338 \$8337 \$8121 VSS \$8738 VDD AOI21_X1
X$11273 \$8338 VSS VDD \$8476 INV_X1
X$11274 \$8338 \$8337 \$8756 VSS \$9103 VDD AOI21_X1
X$11276 \$8979 \$8119 \$8976 VSS \$8709 VDD AOI21_X1
X$11277 \$8600 VSS VDD \$8599 INV_X1
X$11278 \$8600 VSS VDD \$8979 CLKBUF_X1
X$11280 \$8458 VSS VDD \$8881 INV_X1
X$11281 \$8119 VSS VDD \$8884 INV_X1
X$11282 \$8718 \$8990 \$8121 VSS \$8603 VDD AOI21_X1
X$11283 \$8604 VSS VDD \$8605 INV_X1
X$11284 \$8884 \$8605 \$8986 VSS VDD \$8990 NOR3_X1
X$11286 \$8606 \$8337 VSS VDD \$8986 NAND2_X1
X$11287 \$8468 \$8605 VDD VSS \$9684 XNOR2_X1
X$11288 \$9104 VSS VDD \$8336 INV_X1
X$11292 \$8764 VSS VDD \$8335 INV_X1
X$11293 \$8121 \$8752 VSS VDD \$9004 XOR2_X1
X$11294 \$8337 VSS VDD \$8752 CLKBUF_X1
X$11296 \$6348 \$8763 \$8337 VDD VSS \$8338 HA_X1
X$11300 \$8766 VSS VDD \$8340 CLKBUF_X1
X$11301 \$8767 VSS VDD \$8766 CLKBUF_X1
X$11304 \$9004 VSS VDD \$9211 CLKBUF_X1
X$11306 \$7826 \$9106 VDD VSS \$8763 AND2_X1
X$11307 \$8222 \$8889 \$8606 VDD VSS \$8764 HA_X1
X$11310 \$8122 VSS VDD \$8343 CLKBUF_X1
X$11314 \$8344 VSS VDD \$8615 CLKBUF_X1
X$11318 VSS \$7578 \$I99895 \$8892 \$6083 \$6364 VDD DFFR_X1
X$11319 VSS \$7578 \$I99793 \$8893 \$9025 \$6364 VDD DFFR_X1
X$11322 VSS \$7578 \$I99802 \$9030 \$8257 \$6364 VDD DFFR_X1
X$11324 \$8125 VSS VDD \$8345 CLKBUF_X1
X$11325 \$8778 VSS VDD \$8512 CLKBUF_X1
X$11326 \$8346 VSS VDD \$8778 CLKBUF_X1
X$11327 VSS \$8127 \$I100427 \$9041 \$8347 \$6364 VDD DFFR_X1
X$11328 \$8520 VSS VDD \$8789 CLKBUF_X1
X$11329 \$8896 VSS VDD \$8520 CLKBUF_X1
X$11331 \$8898 VSS VDD \$8619 CLKBUF_X1
X$11339 \$8783 VSS VDD \$8347 CLKBUF_X1
X$11340 \$8127 VSS VDD \$I92809 CLKBUF_X1
X$11341 \$8348 VSS VDD \$8783 CLKBUF_X1
X$11342 \$5493 VSS VDD \$8127 CLKBUF_X3
X$11343 VSS \$8127 \$I99816 \$8897 \$8618 \$6364 VDD DFFR_X1
X$11345 VSS \$8127 \$I99854 \$8899 \$9048 \$6364 VDD DFFR_X1
X$11346 \$8350 VSS VDD \$8621 CLKBUF_X1
X$11349 \$8621 VSS VDD \$8622 CLKBUF_X1
X$11350 \$8270 VSS VDD \$8528 CLKBUF_X1
X$11352 \$7582 VSS VDD \$I94106 CLKBUF_X1
X$11353 \$8541 VSS VDD \$8805 CLKBUF_X1
X$11354 \$8269 VSS VDD \$8624 CLKBUF_X1
X$11355 VSS \$7582 \$I100156 \$8627 \$7584 \$6364 VDD DFFR_X1
X$11356 \$8627 VSS VDD \$8355 CLKBUF_X1
X$11357 \$9079 VSS VDD \$8821 CLKBUF_X1
X$11358 \$8357 VSS VDD \$9287 CLKBUF_X1
X$11359 \$8821 VSS VDD \$8839 CLKBUF_X1
X$11360 \$8822 VSS VDD \$7342 CLKBUF_X1
X$11361 \$8629 VSS VDD \$8827 CLKBUF_X1
X$11362 \$8827 VSS VDD \$8833 CLKBUF_X1
X$11363 \$8564 VSS VDD \$8630 CLKBUF_X1
X$11364 \$8833 VSS VDD \$8564 CLKBUF_X1
X$11365 \$8839 VSS VDD \$8837 CLKBUF_X1
X$11368 \$8535 VSS VDD \$9056 CLKBUF_X1
X$11369 \$9056 VSS VDD \$9061 CLKBUF_X1
X$11370 \$9121 VSS VDD \$9062 CLKBUF_X1
X$11371 \$9063 VSS VDD \$8901 CLKBUF_X1
X$11372 \$9061 VSS VDD \$9063 CLKBUF_X1
X$11373 \$8808 VSS VDD \$8625 CLKBUF_X1
X$11374 \$8805 VSS VDD \$8808 CLKBUF_X1
X$11376 \$9067 VSS VDD \$9077 CLKBUF_X1
X$11377 VSS \$7582 \$I99792 \$8357 \$9077 \$6364 VDD DFFR_X1
X$11378 VSS \$7589 \$I99799 \$8631 \$8837 \$6364 VDD DFFR_X1
X$11379 \$8631 VSS VDD \$8359 CLKBUF_X1
X$11380 \$8846 VSS VDD \$8841 CLKBUF_X1
X$11381 \$9084 VSS VDD \$8846 CLKBUF_X1
X$11382 \$9127 VSS VDD \$6313 CLKBUF_X1
X$11384 \$8360 VSS VDD \$8361 CLKBUF_X1
X$11387 \$8578 VSS VDD \$8855 CLKBUF_X1
X$11388 \$8583 VSS VDD \$8135 CLKBUF_X1
X$11389 \$8633 VSS VDD \$8853 CLKBUF_X1
X$11391 \$8853 VSS VDD \$8591 CLKBUF_X1
X$11392 \$8363 VSS VDD \$9131 CLKBUF_X1
X$11393 \$8634 VSS VDD \$8363 CLKBUF_X1
X$11394 \$8861 VSS VDD \$9069 CLKBUF_X1
X$11395 \$8364 VSS VDD \$8861 CLKBUF_X1
X$11397 \$8591 VSS VDD \$8864 CLKBUF_X1
X$11398 \$8584 VSS VDD \$7855 CLKBUF_X1
X$11400 \$8366 VSS VDD \$8865 CLKBUF_X1
X$11401 \$8865 VSS VDD \$8863 CLKBUF_X1
X$11402 \$8863 VSS VDD \$8581 CLKBUF_X1
X$11403 \$8580 VSS VDD \$8868 CLKBUF_X1
X$11405 \$8572 VSS VDD \$8574 CLKBUF_X1
X$11408 VSS \$7589 \$I99806 \$8633 \$9085 \$6763 VDD DFFR_X1
X$11410 VSS \$8635 \$I99857 \$8634 \$8568 \$6763 VDD DFFR_X1
X$11411 VSS \$8635 \$I99817 \$8910 \$9069 \$6763 VDD DFFR_X1
X$11412 \$8864 VSS VDD \$9055 CLKBUF_X1
X$11414 \$9323 VSS VDD \$9052 CLKBUF_X1
X$11415 \$9052 VSS VDD \$8911 CLKBUF_X1
X$11418 \$8868 VSS VDD \$8560 CLKBUF_X1
X$11420 \$8368 VSS VDD \$8142 CLKBUF_X1
X$11421 \$8636 VSS VDD \$8854 CLKBUF_X1
X$11422 VSS \$8146 \$I100442 \$8555 \$8637 \$8370 VDD DFFR_X1
X$11423 \$8854 VSS VDD \$8550 CLKBUF_X1
X$11425 VSS \$8146 \$I100538 \$8832 \$8559 \$8370 VDD DFFR_X1
X$11426 \$6763 VSS VDD \$8370 BUF_X2
X$11427 \$8831 VSS VDD \$8641 CLKBUF_X1
X$11428 \$8545 VSS VDD \$8643 CLKBUF_X1
X$11429 \$8543 VSS VDD \$8644 CLKBUF_X1
X$11430 \$8816 VSS VDD \$8543 CLKBUF_X1
X$11433 \$9313 VSS VDD \$9038 CLKBUF_X1
X$11434 \$9047 VSS VDD \$8856 CLKBUF_X1
X$11436 \$8638 VSS VDD \$9366 CLKBUF_X1
X$11437 \$8836 VSS VDD \$8143 CLKBUF_X1
X$11438 \$5666 VSS VDD \$8146 CLKBUF_X3
X$11439 \$8842 VSS VDD \$8640 CLKBUF_X1
X$11440 \$8914 VSS VDD \$9031 CLKBUF_X1
X$11441 \$9031 VSS VDD \$8842 CLKBUF_X1
X$11442 \$8640 VSS VDD \$8836 CLKBUF_X1
X$11443 \$8832 VSS VDD \$8831 CLKBUF_X1
X$11444 \$8641 VSS VDD \$8816 CLKBUF_X1
X$11445 \$8644 VSS VDD \$8372 CLKBUF_X1
X$11448 \$9021 VSS VDD \$8375 CLKBUF_X1
X$11449 \$8811 VSS VDD \$8148 CLKBUF_X1
X$11451 \$8374 VSS VDD \$8811 CLKBUF_X1
X$11452 \$9015 VSS VDD \$6541 CLKBUF_X1
X$11453 \$9016 VSS VDD \$9018 CLKBUF_X1
X$11454 \$8370 VSS VDD \$4734 BUF_X2
X$11455 VSS \$7609 \$I100531 \$8799 \$8802 \$4734 VDD DFFR_X1
X$11456 VSS \$7609 \$I100544 \$8651 \$8800 \$4734 VDD DFFR_X1
X$11457 VSS \$7609 \$I100514 \$8780 \$9002 \$4734 VDD DFFR_X1
X$11458 \$8780 VSS VDD \$8781 CLKBUF_X1
X$11459 \$8781 VSS VDD \$8381 CLKBUF_X1
X$11464 \$9290 VSS VDD \$9142 CLKBUF_X1
X$11465 \$8643 VSS VDD \$8800 CLKBUF_X1
X$11466 \$8150 VSS VDD \$9021 CLKBUF_X1
X$11468 \$9144 VSS VDD \$8782 CLKBUF_X1
X$11470 \$9014 VSS VDD \$8998 CLKBUF_X1
X$11471 \$9012 VSS VDD \$8154 CLKBUF_X1
X$11472 \$9008 VSS VDD \$8376 CLKBUF_X1
X$11473 \$8918 VSS VDD \$7610 CLKBUF_X1
X$11474 \$8799 VSS VDD \$8053 CLKBUF_X1
X$11477 \$8523 VSS VDD \$7743 CLKBUF_X1
X$11478 \$9006 VSS VDD \$7870 CLKBUF_X1
X$11479 \$8785 VSS VDD \$9006 CLKBUF_X1
X$11480 \$8651 VSS VDD \$8785 CLKBUF_X1
X$11482 VSS \$7618 \$I99923 \$8652 \$8998 \$4734 VDD DFFR_X1
X$11483 \$5415 VSS VDD \$7618 CLKBUF_X3
X$11484 \$8384 VSS VDD \$8513 CLKBUF_X1
X$11485 \$8991 VSS VDD \$8653 CLKBUF_X1
X$11486 \$8773 VSS VDD \$8383 CLKBUF_X1
X$11490 VSS \$7618 \$I99952 \$8386 \$8654 \$6120 VDD DFFR_X1
X$11492 \$8385 VSS VDD \$8500 CLKBUF_X1
X$11493 \$8386 VSS VDD \$8489 CLKBUF_X1
X$11494 \$8489 VSS VDD \$8761 CLKBUF_X1
X$11495 \$8765 VSS VDD \$8973 CLKBUF_X1
X$11496 \$8758 VSS VDD \$8765 CLKBUF_X1
X$11499 \$8482 VSS VDD \$8740 CLKBUF_X1
X$11500 \$8751 VSS VDD \$8750 CLKBUF_X1
X$11501 \$8655 VSS VDD \$8751 CLKBUF_X1
X$11502 \$8750 VSS VDD \$8482 CLKBUF_X1
X$11503 \$8926 VSS VDD \$7370 CLKBUF_X1
X$11504 \$8740 VSS VDD \$8722 CLKBUF_X1
X$11507 VSS \$7875 \$I99858 \$8655 \$8967 \$6120 VDD DFFR_X1
X$11509 VSS \$7875 \$I99922 \$6987 \$8951 \$6120 VDD DFFR_X1
X$11510 \$8474 VSS VDD \$8471 CLKBUF_X1
X$11512 \$7233 VSS VDD \$I93765 CLKBUF_X1
X$11513 \$6987 VSS VDD \$8720 CLKBUF_X1
X$11515 \$8720 VSS VDD \$8463 CLKBUF_X1
X$11516 \$9151 VSS VDD \$8391 CLKBUF_X1
X$11518 VSS \$7233 \$I99808 \$6564 \$8954 \$6120 VDD DFFR_X1
X$11519 \$8392 VSS VDD \$7688 CLKBUF_X1
X$11520 \$8437 VSS VDD \$8436 CLKBUF_X1
X$11521 \$8450 VSS VDD \$8448 CLKBUF_X1
X$11522 \$6564 VSS VDD \$7376 CLKBUF_X1
X$11523 \$8393 VSS VDD \$7883 CLKBUF_X1
X$11526 \$8658 \$6986 VSS VDD \$8711 NAND2_X1
X$11528 \$8711 VSS VDD \$8704 INV_X1
X$11530 \$7869 \$6379 VSS VDD \$8660 NAND2_X1
X$11531 \$8660 VSS VDD \$8432 INV_X1
X$11533 \$8704 \$8432 \$8703 VDD VSS \$8692 HA_X1
X$11539 VSS \$8703 \$8948 \$8946 \$8698 \$8190 VDD FA_X1
X$11540 VSS \$8397 \$8698 \$8694 \$8695 \$8420 VDD FA_X1
X$11541 \$8396 VSS VDD \$8420 INV_X1
X$11542 \$8694 \$8412 \$8407 VDD VSS \$8693 HA_X1
X$11546 VSS \$8693 \$9415 \$8662 \$9163 \$8946 VDD FA_X1
X$11548 VSS \$8685 \$8690 \$8663 \$8662 \$8176 VDD FA_X1
X$11550 \$8664 VSS VDD \$8679 INV_X1
X$11551 \$8679 \$8399 \$8666 VDD VSS \$8667 HA_X1
X$11553 \$8670 VSS VDD \$8668 INV_X1
X$11565 \$8398 \$8663 \$8934 VDD VSS \$8945 HA_X1
X$11566 \$8945 VSS VDD \$8681 INV_X1
X$11567 \$8934 \$8666 VSS VDD \$8665 NAND2_X1
X$11568 \$8665 VSS VDD \$8936 INV_X1
X$11569 VSS \$8664 \$8935 \$9401 \$8940 \$8668 VDD FA_X1
X$11591 \$12607 \$13472 VDD VSS \$13211 XNOR2_X1
X$11592 \$13211 \$13362 VDD VSS \$13267 XNOR2_X1
X$11593 \$13123 \$13267 VDD VSS \$13000 XNOR2_X1
X$11597 \$13362 VSS VDD \$12940 INV_X1
X$11604 \$13367 VSS VDD \$13533 INV_X1
X$11607 \$12523 \$10452 VSS VDD \$13628 NAND2_X1
X$11608 \$12450 \$9658 VSS VDD \$13214 NAND2_X1
X$11609 \$13214 VSS VDD \$13551 INV_X1
X$11611 \$12450 \$8444 VSS VDD \$13216 NAND2_X1
X$11613 \$13216 VSS VDD \$13291 INV_X1
X$11614 \$12523 \$8987 VSS VDD \$13292 NAND2_X1
X$11616 \$12944 \$13000 VDD VSS \$13131 XNOR2_X1
X$11618 \$13015 VSS VDD \$12691 INV_X1
X$11623 \$12946 \$13397 \$13143 VDD VSS \$13144 HA_X1
X$11624 \$13144 \$13143 \$13142 VSS \$13090 VDD AOI21_X1
X$11627 \$13093 VSS VDD \$13095 INV_X1
X$11628 \$13092 VSS VDD \$13091 CLKBUF_X1
X$11629 \$13093 \$12952 VSS VDD \$13152 NAND2_X1
X$11630 \$12947 VSS VDD \$13093 CLKBUF_X1
X$11631 \$13150 VSS VDD \$12464 CLKBUF_X3
X$11632 \$12464 VSS VDD \$I69137 INV_X1
X$11633 \$13152 \$13097 \$12951 VDD \$13155 VSS OAI21_X1
X$11634 \$13096 VSS VDD \$12951 INV_X1
X$11636 \$12953 \$13095 \$12950 VDD \$13096 VSS OAI21_X1
X$11639 \$13097 \$12952 VDD VSS \$13036 XNOR2_X1
X$11640 \$13230 VSS VDD \$12952 CLKBUF_X1
X$11647 \$13015 \$10452 VSS VDD \$13221 NAND2_X1
X$11648 \$13221 VSS VDD \$13279 INV_X1
X$11651 \$12618 \$8444 VSS VDD \$13137 NAND2_X1
X$11653 \$13137 VSS VDD \$13395 INV_X1
X$11654 \$13298 \$13395 \$12708 VDD VSS \$13572 HA_X1
X$11658 \$13091 VSS VDD \$13300 CLKBUF_X1
X$11661 \$12950 \$13303 \$13304 VDD \$13302 VSS OAI21_X1
X$11663 \$13095 VSS VDD \$13411 CLKBUF_X1
X$11664 \$13095 \$13227 \$12950 VDD \$13410 VSS OAI21_X1
X$11665 \$13229 VSS VDD \$13227 INV_X1
X$11666 \$13229 \$13411 VDD VSS \$13741 XNOR2_X1
X$11669 \$13232 \$13307 \$12953 VDD \$13229 VSS OAI21_X1
X$11670 \$12952 VSS VDD \$13232 INV_X1
X$11671 \$13233 \$13232 \$12953 \$13308 \$13310 VDD VSS \$13600 OAI221_X1
X$11672 \$13230 \$13175 VSS VDD \$13308 NAND2_X1
X$11674 \$13099 \$13178 \$13175 VDD VSS \$13431 HA_X1
X$11676 \$13177 \$13175 VSS VDD \$13440 NAND2_X1
X$11677 \$12839 \$13181 \$13100 VDD VSS \$13177 HA_X1
X$11678 \$13177 VSS VDD \$13101 INV_X1
X$11683 \$13431 \$13175 \$13427 VSS \$13307 VDD AOI21_X1
X$11684 \$13431 VSS VDD \$13233 INV_X1
X$11685 \$13175 VSS VDD \$13312 CLKBUF_X1
X$11686 \$13283 VSS VDD \$13310 INV_X1
X$11688 \$13312 VSS VDD \$13313 INV_X1
X$11689 \$13316 \$13314 \$13315 VSS \$13097 VDD AOI21_X1
X$11690 \$13440 \$13233 \$13436 VSS VDD \$13316 NAND3_X1
X$11691 \$13175 \$13100 \$13451 VSS VDD \$13436 NAND3_X1
X$11693 \$13322 \$13321 \$13101 VDD \$13283 VSS OAI21_X1
X$11698 \$13237 VSS VDD \$13323 CLKBUF_X1
X$11699 VSS \$12600 \$I100123 \$13325 \$12921 \$10386 VDD DFFR_X1
X$11700 VSS \$12600 \$I99938 \$13791 \$12840 \$10386 VDD DFFR_X1
X$11701 VSS \$13622 \$I99932 \$13326 \$12928 \$10386 VDD DFFR_X1
X$11703 \$13240 VSS VDD \$12538 CLKBUF_X1
X$11705 \$12247 VSS VDD \$13056 INV_X1
X$11708 VSS \$11440 \$I100168 \$4936 \$13188 \$10386 VDD DFFR_X1
X$11711 \$12958 VSS VDD \$13799 INV_X1
X$11714 \$13468 VSS VDD \$13188 CLKBUF_X1
X$11715 \$13241 VSS VDD \$13468 CLKBUF_X1
X$11716 \$13499 VSS VDD \$13242 CLKBUF_X1
X$11719 \$13469 VSS VDD \$12959 CLKBUF_X1
X$11721 \$13663 VSS VDD \$12410 CLKBUF_X1
X$11725 \$13329 \$13245 VDD VSS \$13281 XNOR2_X1
X$11727 VSS \$12414 \$13330 \$13606 \$12842 \$12926 VDD FA_X1
X$11730 \$12962 VSS VDD \$13460 INV_X1
X$11738 VSS \$13246 \$13502 \$13664 \$13460 \$13332 VDD FA_X1
X$11742 \$13456 VSS VDD \$13504 INV_X1
X$11746 VSS \$12635 \$13914 \$13333 \$12258 \$13591 VDD FA_X1
X$11749 \$12965 \$12964 \$13503 VDD VSS \$13103 HA_X1
X$11751 \$13209 VSS VDD \$11539 CLKBUF_X1
X$11756 \$13503 VSS VDD \$13210 INV_X1
X$11759 VSS \$13210 \$13447 \$13442 \$12636 \$13080 VDD FA_X1
X$11760 \$2886 VSS VDD \$9943 CLKBUF_X3
X$11763 \$12917 VSS VDD \$13437 INV_X1
X$11765 VSS \$12425 \$13445 \$13104 \$12264 \$13207 VDD FA_X1
X$11769 VSS \$13204 \$13421 \$13416 \$12500 \$13105 VDD FA_X1
X$11771 \$12848 \$12911 \$13274 VDD VSS \$13106 HA_X1
X$11773 \$13194 VSS VDD \$11524 CLKBUF_X1
X$11774 \$12969 VSS VDD \$13344 INV_X1
X$11775 \$13191 \$11782 \$13195 VDD VSS \$12970 HA_X1
X$11776 \$13196 VSS VDD \$13191 INV_X1
X$11777 \$13195 VSS VDD \$13250 INV_X1
X$11780 \$13445 VSS VDD \$13335 INV_X1
X$11783 \$12968 VSS VDD \$13428 INV_X1
X$11784 \$13104 VSS VDD \$13336 INV_X1
X$11787 \$13421 VSS VDD \$13512 INV_X1
X$11791 VSS \$13106 \$13339 \$13273 \$13416 \$12912 VDD FA_X1
X$11793 \$14046 VSS VDD \$12017 CLKBUF_X1
X$11795 VSS \$12970 \$13342 \$13886 \$13274 \$13344 VDD FA_X1
X$11798 VSS \$13107 \$13839 \$13345 \$13250 \$12971 VDD FA_X1
X$11799 \$12642 VSS VDD \$13107 INV_X1
X$11805 \$13108 \$13066 VDD VSS \$13170 XNOR2_X1
X$11806 \$12852 \$12851 VDD VSS \$13066 XNOR2_X1
X$11811 \$13182 VSS VDD \$13169 INV_X1
X$11812 \$12974 \$13062 \$13179 VDD VSS \$13182 HA_X1
X$11813 \$13179 VSS VDD \$13109 INV_X1
X$11817 \$13109 \$13166 \$13169 VDD \$13251 VSS OAI21_X1
X$11820 \$13047 \$13173 \$13110 VDD VSS \$13111 HA_X1
X$11822 \$13111 \$13110 \$12978 VSS \$13166 VDD AOI21_X1
X$11823 \$13111 VSS VDD \$13154 INV_X1
X$11825 \$13110 VSS VDD \$12975 INV_X1
X$11827 \$12975 \$12857 \$13154 VDD \$12976 VSS OAI21_X1
X$11828 \$12976 \$13109 VDD VSS \$13140 XNOR2_X1
X$11829 \$12978 \$12975 VDD VSS \$13252 XNOR2_X1
X$11831 \$12860 VSS VDD \$I101703 INV_X2
X$11832 VSS \$12860 \$I100233 \$13135 \$12979 \$9850 VDD DFFR_X1
X$11835 \$13251 \$13170 VDD VSS \$13270 XNOR2_X1
X$11839 VSS \$12860 \$I99966 \$13347 \$13252 \$9850 VDD DFFR_X1
X$11842 \$13348 \$13353 VSS VDD \$13254 NAND2_X1
X$11843 \$13254 \$12887 \$13255 VDD \$13681 VSS OAI21_X1
X$11844 \$13135 VSS VDD \$13401 CLKBUF_X1
X$11848 \$13401 \$13398 \$13352 VDD VSS \$13393 HA_X1
X$11849 \$13393 VSS VDD \$13259 INV_X1
X$11850 \$12887 \$13353 VDD VSS \$13257 XNOR2_X1
X$11852 VSS \$13118 \$I100454 \$13115 \$13114 \$9850 VDD DFFR_X1
X$11853 \$12981 VSS VDD \$13028 INV_X1
X$11855 \$13257 VSS VDD \$13114 CLKBUF_X1
X$11859 \$13353 VSS VDD \$13258 INV_X1
X$11860 \$13258 \$13355 \$13259 VDD \$13523 VSS OAI21_X1
X$11861 \$12981 \$12861 \$13356 VSS \$13355 VDD AOI21_X1
X$11862 \$13352 \$12861 VSS VDD \$13261 NAND2_X1
X$11863 \$13028 \$13258 \$13259 \$13261 \$13263 VDD VSS \$14000 OAI221_X1
X$11865 \$12861 VSS VDD \$13129 CLKBUF_X1
X$11866 \$13129 VSS VDD \$12985 INV_X1
X$11867 \$12654 \$12653 VSS VDD \$13262 NAND2_X1
X$11868 \$12183 \$12869 VDD VSS \$13124 XNOR2_X1
X$11869 VSS \$13118 \$I100461 \$12995 \$13121 \$9850 VDD DFFR_X1
X$11880 \$13261 \$13262 VSS VDD \$14015 NOR2_X1
X$11882 \$13262 \$12183 \$13263 VDD \$13356 VSS OAI21_X1
X$11883 \$12985 VSS VDD \$13357 CLKBUF_X1
X$11884 \$12987 VSS VDD \$13263 INV_X1
X$11885 \$13124 VSS VDD \$13121 CLKBUF_X1
X$11888 \$12990 VSS VDD \$13358 CLKBUF_X1
X$11891 \$12177 \$12995 \$13359 \$13360 VDD \$13266 VSS NOR4_X2
X$11916 \$5908 VSS VDD yout[3] BUF_X1
X$11919 \$12825 \$13088 VDD VSS \$12823 XNOR2_X1
X$11923 \$12823 \$12606 VDD VSS \$13123 XNOR2_X1
X$11925 \$12876 \$12824 VDD VSS \$12606 XNOR2_X1
X$11926 VSS \$12826 \$12824 \$13004 \$12878 \$12940 VDD FA_X1
X$11927 \$12671 VSS VDD \$12670 INV_X1
X$11928 VSS \$12673 \$12876 \$12878 \$12825 \$12670 VDD FA_X1
X$11931 \$12941 VSS VDD \$12825 INV_X1
X$11933 \$13006 VSS VDD \$12826 INV_X1
X$11934 VSS \$12888 \$13006 \$13367 \$12610 \$12941 VDD FA_X1
X$11935 VSS \$12883 \$12671 \$12610 \$12678 \$12609 VDD FA_X1
X$11937 \$12611 VSS VDD \$12883 INV_X1
X$11939 \$12525 \$10452 VSS VDD \$12678 NOR2_X1
X$11942 VSS \$12614 \$12888 \$13009 \$12683 \$12615 VDD FA_X1
X$11943 \$12890 VSS VDD \$12615 INV_X1
X$11944 \$12523 \$11303 VSS VDD \$12890 NAND2_X1
X$11948 \$12827 \$8444 VSS VDD \$12616 NAND2_X1
X$11949 \$12616 VSS VDD \$12698 INV_X1
X$11951 \$12898 \$12698 \$12617 VDD VSS \$12831 HA_X1
X$11954 \$12708 \$12834 \$12833 VDD VSS \$12835 HA_X1
X$11959 \$13009 VSS VDD \$13541 INV_X1
X$11962 \$12450 \$12523 VSS VDD \$13011 XOR2_X1
X$11965 \$13011 \$11743 VSS VDD \$12944 NAND2_X1
X$11968 \$13015 \$8987 VSS VDD \$12828 NAND2_X1
X$11969 \$12828 VSS VDD \$12898 INV_X1
X$11971 \$13015 \$9658 VSS VDD \$12829 NAND2_X1
X$11972 \$12829 VSS VDD \$13021 INV_X1
X$11973 \$12827 \$8987 VSS VDD \$12830 NAND2_X1
X$11974 \$12830 VSS VDD \$13020 INV_X1
X$11975 \$13021 \$13020 \$13022 VDD VSS \$13138 HA_X1
X$11976 \$12831 \$13022 \$12834 VDD VSS \$13027 HA_X1
X$11978 VSS \$12835 \$12946 \$12713 \$13224 \$13027 VDD FA_X1
X$11979 \$12836 \$12709 \$12592 VSS \$13142 VDD AOI21_X1
X$11981 \$12713 VSS VDD \$12836 INV_X1
X$11984 \$12394 VSS VDD \$13092 CLKBUF_X1
X$11986 \$12717 VSS VDD \$12948 CLKBUF_X1
X$11993 \$12948 \$13098 \$12947 VDD VSS \$13032 HA_X1
X$11994 \$13032 VSS VDD \$12950 INV_X1
X$11997 \$12837 \$13041 \$13230 VDD VSS \$13040 HA_X1
X$11998 \$12620 VSS VDD \$12837 CLKBUF_X1
X$12000 VSS \$12464 \$I100456 \$13043 \$12719 \$12319 VDD DFFR_X1
X$12005 \$12622 \$12403 VDD VSS \$12921 XNOR2_X1
X$12006 \$12733 \$12924 VSS VDD \$12622 NAND2_X1
X$12007 \$12624 \$12536 VDD VSS \$12840 XNOR2_X1
X$12008 \$12743 VSS VDD \$12600 CLKBUF_X3
X$12009 \$12536 \$12750 VSS VDD \$12924 NAND2_X1
X$12010 \$12624 VSS VDD \$12730 INV_X1
X$12014 \$13036 VSS VDD \$12719 CLKBUF_X1
X$12015 \$13040 VSS VDD \$12953 INV_X1
X$12018 \$13043 VSS VDD \$12954 INV_X1
X$12023 \$12955 VSS VDD \$13099 CLKBUF_X1
X$12026 \$13045 VSS VDD \$12839 CLKBUF_X1
X$12031 VSS \$12532 \$I100112 \$13237 \$12956 \$10386 VDD DFFR_X1
X$12038 \$12600 VSS VDD \$I101695 INV_X2
X$12042 \$12841 \$12407 VDD VSS \$12928 XNOR2_X1
X$12043 \$12841 \$12625 \$12755 VDD \$12750 VSS OAI21_X1
X$12044 \$12407 VSS VDD \$12625 INV_X1
X$12045 \$12753 \$12932 \$12627 VSS \$12624 VDD AOI21_X1
X$12046 \$12763 \$12625 \$12755 VDD \$12753 VSS OAI21_X1
X$12047 \$12626 \$12247 \$12933 VDD VSS \$12764 HA_X1
X$12048 \$12764 VSS VDD \$12763 INV_X1
X$12053 \$13053 VSS VDD \$12932 INV_X1
X$12054 \$12407 \$12933 VSS VDD \$13053 NAND2_X1
X$12055 VSS \$12539 \$12841 \$12958 \$13056 \$13058 VDD FA_X1
X$12056 \$12627 VSS VDD \$13058 INV_X1
X$12059 \$11989 \$12762 \$12937 VDD VSS \$12627 HA_X1
X$12063 \$12959 VSS VDD \$12361 CLKBUF_X1
X$12064 \$11440 VSS VDD \$I101696 INV_X2
X$12065 \$12743 VSS VDD \$11440 CLKBUF_X3
X$12066 \$13243 VSS VDD \$12411 CLKBUF_X1
X$12068 \$13244 VSS VDD \$12249 CLKBUF_X1
X$12070 VSS \$13067 \$13465 \$12961 \$12842 \$12629 VDD FA_X1
X$12071 \$12927 \$12628 VDD VSS \$13245 XNOR2_X1
X$12073 \$12628 VSS VDD \$13067 INV_X1
X$12075 \$12412 \$12777 \$12628 VDD VSS \$12927 HA_X1
X$12077 \$12630 VSS VDD \$12843 INV_X1
X$12080 VSS \$12633 \$12844 \$12963 \$12634 \$12583 VDD FA_X1
X$12085 \$12584 VSS VDD \$12926 INV_X1
X$12087 \$12963 VSS VDD \$12842 INV_X1
X$12088 VSS \$12843 \$13331 \$12962 \$12842 \$12631 VDD FA_X1
X$12091 VSS \$12845 \$13246 \$13456 \$12418 \$12963 VDD FA_X1
X$12094 VSS \$12920 \$13454 \$12795 \$12792 \$12634 VDD FA_X1
X$12095 \$12795 VSS VDD \$12798 INV_X1
X$12099 VSS \$12919 \$13080 \$12818 \$12801 \$10488 VDD FA_X1
X$12103 \$13079 VSS VDD \$12965 INV_X1
X$12104 \$12919 VSS VDD \$12964 INV_X1
X$12108 \$12810 VSS VDD \$12816 INV_X1
X$12110 \$12816 \$12817 \$12916 VDD VSS \$12967 HA_X1
X$12111 \$12818 VSS VDD \$13084 INV_X1
X$12114 \$12579 VSS VDD \$12800 INV_X1
X$12115 \$12800 \$12802 \$12913 VDD VSS \$12847 HA_X1
X$12118 VSS \$12913 \$12912 \$12848 \$12794 \$12785 VDD FA_X1
X$12124 VSS \$13084 \$12917 \$13207 \$11592 \$12967 VDD FA_X1
X$12127 VSS \$12916 \$12968 \$13105 \$12160 \$12847 VDD FA_X1
X$12133 \$12265 \$12640 \$12911 VDD VSS \$13204 HA_X1
X$12139 VSS \$12577 \$12969 \$13196 \$13072 \$12641 VDD FA_X1
X$12140 \$12781 VSS VDD \$13072 INV_X1
X$12144 \$12062 \$12467 \$12910 VDD VSS \$12849 HA_X1
X$12146 \$11912 \$12276 VDD VSS \$12852 XNOR2_X1
X$12151 \$12849 VSS VDD \$12971 INV_X1
X$12156 \$12850 \$13069 VDD VSS \$12851 XNOR2_X1
X$12157 VSS \$12431 \$13069 \$12973 \$13064 \$12972 VDD FA_X1
X$12158 \$12276 VSS VDD \$13064 INV_X1
X$12159 \$12973 VSS VDD \$13062 INV_X1
X$12161 VSS \$12646 \$12974 \$13173 \$12854 \$12276 VDD FA_X1
X$12162 \$12645 VSS VDD \$12854 INV_X1
X$12166 VSS \$12907 \$12855 \$12727 \$12906 \$12728 VDD FA_X1
X$12171 \$12855 VSS VDD \$13047 INV_X1
X$12174 \$12727 VSS VDD \$12723 INV_X1
X$12176 \$12647 \$12723 \$12856 VDD VSS \$12721 HA_X1
X$12178 \$12721 \$12856 \$12902 VSS \$12857 VDD AOI21_X1
X$12179 \$12721 VSS VDD \$12859 INV_X1
X$12182 \$12856 VSS VDD \$13044 INV_X1
X$12184 \$13044 \$12557 \$12859 VDD \$12978 VSS OAI21_X1
X$12187 \$12648 \$12856 VDD VSS \$12979 XNOR2_X1
X$12188 \$12648 VSS VDD \$12902 INV_X1
X$12194 \$12690 VSS VDD \$13034 CLKBUF_X1
X$12199 \$13037 VSS VDD \$12860 CLKBUF_X3
X$12202 \$13034 \$13033 \$12861 VDD VSS \$12981 HA_X1
X$12203 \$12650 VSS VDD \$12687 CLKBUF_X1
X$12205 \$12687 \$12651 \$12865 VDD VSS \$12863 HA_X1
X$12210 \$12863 \$12861 VSS VDD \$12862 NAND2_X1
X$12211 \$12862 \$13028 \$12652 VSS VDD \$12983 NAND3_X1
X$12212 \$12983 \$12882 \$11926 VSS \$12887 VDD AOI21_X1
X$12213 \$12653 VSS VDD \$12866 INV_X1
X$12214 \$12861 \$12865 \$12680 VSS VDD \$12652 NAND3_X1
X$12215 \$12654 \$12176 VSS VDD \$12867 NAND2_X1
X$12217 \$12675 \$12656 \$12657 VDD \$12680 VSS OAI21_X1
X$12218 \$12869 VSS VDD \$12656 INV_X1
X$12219 \$12656 \$12659 \$12657 VDD \$12870 VSS OAI21_X1
X$12220 \$12559 \$12875 \$12654 VDD VSS \$12660 HA_X1
X$12221 \$12660 VSS VDD \$12657 INV_X1
X$12228 \$12865 VSS VDD \$12653 CLKBUF_X1
X$12229 \$12985 \$12866 \$12867 VSS VDD \$12882 NOR3_X1
X$12230 \$12863 VSS VDD \$12988 INV_X1
X$12231 \$12657 \$12866 \$12988 VDD \$12987 VSS OAI21_X1
X$12232 \$12870 \$12989 VDD VSS \$12990 XNOR2_X1
X$12233 \$12866 VSS VDD \$12989 CLKBUF_X1
X$12234 \$10421 \$12995 VDD VSS \$12875 AND2_X1
X$12238 \$12654 VSS VDD \$12869 CLKBUF_X1
X$12250 \$5432 VSS VDD \$5226 CLKBUF_X1
X$12251 \$4480 VSS VDD \$I93645 CLKBUF_X1
X$12252 \$5362 VSS VDD \$5434 CLKBUF_X1
X$12254 \$5437 VSS VDD \$5362 CLKBUF_X1
X$12255 \$5436 VSS VDD \$5437 CLKBUF_X1
X$12256 \$5171 VSS VDD \$5232 CLKBUF_X1
X$12257 \$5231 VSS VDD \$5432 CLKBUF_X1
X$12259 \$4483 VSS VDD \$4769 CLKBUF_X1
X$12263 dxin[4] VSS VDD \$5611 BUF_X1
X$12265 VSS \$5715 \$I99929 \$5566 \$5611 \$3006 VDD DFFR_X1
X$12269 \$5613 VSS VDD \$5567 CLKBUF_X1
X$12270 \$5566 VSS VDD \$5436 CLKBUF_X1
X$12274 \$5617 VSS VDD \$5442 CLKBUF_X1
X$12275 \$5797 VSS VDD \$5568 CLKBUF_X1
X$12276 \$5446 VSS VDD \$5617 CLKBUF_X1
X$12277 VSS \$4944 \$I100307 \$4945 \$5442 \$3006 VDD DFFR_X1
X$12279 VSS \$4944 \$I100502 \$5368 \$5443 \$3006 VDD DFFR_X1
X$12280 \$5455 VSS VDD \$5253 CLKBUF_X1
X$12281 \$5368 VSS VDD \$5454 CLKBUF_X1
X$12282 \$5454 VSS VDD \$5455 CLKBUF_X1
X$12286 \$5179 VSS VDD \$5180 CLKBUF_X1
X$12289 \$5181 VSS VDD \$5262 CLKBUF_X1
X$12290 \$5458 VSS VDD \$5369 CLKBUF_X1
X$12291 \$5272 VSS VDD \$5458 CLKBUF_X1
X$12292 \$5369 VSS VDD \$4955 CLKBUF_X1
X$12293 \$4501 VSS VDD \$4696 CLKBUF_X1
X$12294 VSS \$4260 \$I100475 \$5371 \$5462 \$3833 VDD DFFR_X1
X$12296 \$5473 VSS VDD \$5277 CLKBUF_X1
X$12297 VSS \$4260 \$I100166 \$5280 \$5468 \$3833 VDD DFFR_X1
X$12299 \$5958 VSS VDD \$5569 CLKBUF_X1
X$12300 \$5570 VSS VDD \$5443 CLKBUF_X1
X$12301 VSS \$4944 \$I99989 \$5571 \$5802 \$3006 VDD DFFR_X1
X$12303 \$5971 VSS VDD \$5572 CLKBUF_X1
X$12304 VSS \$5366 \$I99941 \$5637 \$5365 \$3006 VDD DFFR_X1
X$12305 \$5637 VSS VDD \$5642 CLKBUF_X1
X$12306 \$5642 VSS VDD \$5811 CLKBUF_X1
X$12309 \$1692 VSS VDD \$4954 CLKBUF_X3
X$12311 \$5575 VSS VDD \$5462 CLKBUF_X1
X$12312 \$5064 VSS VDD \$5575 CLKBUF_X1
X$12313 \$5371 VSS VDD \$5649 CLKBUF_X1
X$12314 \$5649 VSS VDD \$5576 CLKBUF_X1
X$12315 \$5653 VSS VDD \$5372 CLKBUF_X1
X$12316 \$5576 VSS VDD \$5653 CLKBUF_X1
X$12317 \$5470 VSS VDD \$5468 CLKBUF_X1
X$12318 \$5733 VSS VDD \$5470 CLKBUF_X1
X$12319 \$5654 VSS VDD \$5659 CLKBUF_X1
X$12320 \$5372 VSS VDD \$5654 CLKBUF_X1
X$12321 \$4844 VSS VDD \$5473 CLKBUF_X1
X$12322 \$5280 VSS VDD \$5822 CLKBUF_X1
X$12323 VSS \$4260 \$I99827 \$5826 \$5659 \$3833 VDD DFFR_X1
X$12324 \$5283 VSS VDD \$5085 CLKBUF_X1
X$12325 \$5482 VSS VDD \$5374 CLKBUF_X1
X$12326 \$4700 VSS VDD \$5298 CLKBUF_X1
X$12327 \$4699 VSS VDD \$5099 CLKBUF_X1
X$12328 \$5185 VSS VDD \$5487 CLKBUF_X1
X$12329 \$5487 VSS VDD \$5186 CLKBUF_X1
X$12330 \$5187 VSS VDD \$5375 CLKBUF_X1
X$12332 \$4506 VSS VDD \$I93729 CLKBUF_X1
X$12333 \$5376 VSS VDD \$5491 CLKBUF_X1
X$12334 \$5305 VSS VDD \$5376 CLKBUF_X1
X$12335 \$5313 VSS VDD \$5309 CLKBUF_X1
X$12336 \$5491 VSS VDD \$4701 CLKBUF_X1
X$12337 \$5493 VSS VDD \$4506 CLKBUF_X3
X$12340 \$5667 VSS VDD \$5830 CLKBUF_X1
X$12342 \$5186 VSS VDD \$5187 CLKBUF_X1
X$12343 \$5670 VSS VDD \$5907 CLKBUF_X1
X$12344 \$6016 VSS VDD \$5577 CLKBUF_X1
X$12345 \$5675 VSS VDD \$5840 CLKBUF_X1
X$12346 \$5577 VSS VDD \$5578 CLKBUF_X1
X$12347 \$6010 VSS VDD \$5675 CLKBUF_X1
X$12349 \$6026 VSS VDD \$5580 CLKBUF_X1
X$12350 \$5579 VSS VDD \$6661 CLKBUF_X1
X$12351 \$5496 VSS VDD \$5377 CLKBUF_X1
X$12352 \$5736 VSS VDD \$5496 CLKBUF_X1
X$12353 \$4966 VSS VDD \$5313 CLKBUF_X1
X$12354 \$5378 VSS VDD \$5379 CLKBUF_X1
X$12356 \$5377 VSS VDD \$5378 CLKBUF_X1
X$12357 \$5379 VSS VDD \$5682 CLKBUF_X1
X$12358 \$5682 VSS VDD \$5850 CLKBUF_X1
X$12359 \$5189 VSS VDD \$5500 CLKBUF_X1
X$12360 \$5500 VSS VDD \$5380 CLKBUF_X1
X$12361 \$5380 VSS VDD \$4703 CLKBUF_X1
X$12362 \$4968 VSS VDD \$5190 CLKBUF_X1
X$12363 \$5382 VSS VDD \$5383 CLKBUF_X1
X$12364 \$5190 VSS VDD \$5318 CLKBUF_X1
X$12366 \$5740 VSS VDD \$5119 CLKBUF_X1
X$12367 \$5324 VSS VDD \$5510 CLKBUF_X1
X$12368 \$5508 VSS VDD \$5327 CLKBUF_X1
X$12369 \$5510 VSS VDD \$5508 CLKBUF_X1
X$12370 \$5327 VSS VDD \$5511 CLKBUF_X1
X$12371 \$5325 VSS VDD \$5324 CLKBUF_X1
X$12373 \$5384 VSS VDD \$5385 CLKBUF_X1
X$12374 \$5192 VSS VDD \$5384 CLKBUF_X1
X$12376 \$5522 \$5389 VSS VDD \$4273 NAND2_X1
X$12377 \$5195 VSS VDD \$5526 CLKBUF_X1
X$12379 \$5526 \$5196 VSS VDD \$5343 NOR2_X1
X$12380 \$5197 VSS VDD \$4274 CLKBUF_X1
X$12381 \$5389 VSS VDD \$5344 INV_X1
X$12385 \$5534 VSS VDD \$5748 CLKBUF_X1
X$12387 \$5354 \$5543 VSS VDD \$5711 NAND2_X1
X$12388 \$4713 VSS VDD \$6287 CLKBUF_X1
X$12389 \$5537 \$4973 VDD VSS \$5193 XNOR2_X1
X$12390 \$5396 \$5392 VDD VSS \$5356 XNOR2_X1
X$12391 \$5198 \$5393 VSS VDD \$5543 NAND2_X1
X$12392 \$5200 VSS VDD \$5198 INV_X1
X$12394 \$2588 VSS VDD \$6083 BUF_X1
X$12396 \$5686 VSS VDD \$5688 CLKBUF_X1
X$12397 \$5739 VSS VDD \$5686 CLKBUF_X1
X$12398 \$5688 VSS VDD \$5382 CLKBUF_X1
X$12399 \$5383 VSS VDD \$5690 CLKBUF_X1
X$12400 \$5690 VSS VDD \$5742 CLKBUF_X1
X$12402 \$5511 VSS VDD \$5696 CLKBUF_X1
X$12403 VSS \$4510 \$5584 \$I86904 \$5696 \$45 VDD DFFR_X1
X$12405 \$5700 \$5193 VSS VDD \$5381 NOR2_X1
X$12406 \$5700 \$4970 VSS VDD \$5565 NOR2_X1
X$12410 \$5583 VSS VDD \$4271 CLKBUF_X1
X$12412 \$5746 \$6278 \$5195 VDD VSS \$5712 HA_X1
X$12413 \$5712 VSS VDD \$5522 INV_X1
X$12414 \$5195 \$5196 VSS VDD \$5389 NAND2_X1
X$12415 \$5712 \$5195 \$6053 VSS \$3771 VDD AOI21_X1
X$12417 \$5584 \$5875 \$5390 VDD VSS \$5714 HA_X1
X$12418 \$5714 VSS VDD \$5585 INV_X1
X$12422 \$5711 \$5706 \$5750 VSS \$4926 VDD AOI21_X1
X$12423 \$5587 \$5586 \$5394 VDD \$5537 VSS OAI21_X1
X$12424 \$5392 VSS VDD \$5587 INV_X1
X$12425 \$5889 \$5587 \$5394 VDD \$5393 VSS OAI21_X1
X$12426 \$5589 \$5392 \$5396 VSS \$5199 VDD AOI21_X1
X$12427 \$5554 VSS VDD \$5397 CLKBUF_X1
X$12431 \$4280 VSS VDD \$5399 CLKBUF_X1
X$12433 \$5558 VSS VDD \$5400 CLKBUF_X1
X$12436 \$5202 \$5679 VSS VDD \$5204 NAND2_X1
X$12442 \$5589 VSS VDD \$5394 INV_X1
X$12443 \$5867 \$5694 \$5392 VDD VSS \$5589 HA_X1
X$12445 \$5400 VSS VDD \$5590 CLKBUF_X1
X$12446 \$5559 VSS VDD \$5694 INV_X1
X$12449 \$4974 VSS VDD \$5681 INV_X1
X$12451 \$5679 \$5202 VDD VSS \$5873 XNOR2_X1
X$12455 \$5681 \$5680 \$5857 VSS VDD \$4714 NAND3_X1
X$12459 \$5678 VSS VDD \$5862 INV_X1
X$12462 VSS \$5206 \$5591 \$5755 \$5676 \$5592 VDD FA_X1
X$12463 \$5564 VSS VDD \$5676 INV_X1
X$12466 VSS \$5563 \$5593 \$5848 \$5207 \$5208 VDD FA_X1
X$12467 \$5561 VSS VDD \$5563 INV_X1
X$12468 \$4725 \$5315 \$5851 VDD VSS \$5561 HA_X1
X$12469 \$5210 VSS VDD \$5315 INV_X1
X$12474 \$5593 VSS VDD \$6013 INV_X1
X$12478 \$5594 VSS VDD \$4983 CLKBUF_X1
X$12479 \$5595 VSS VDD \$5403 CLKBUF_X1
X$12481 \$5403 VSS VDD \$4728 CLKBUF_X1
X$12482 \$5596 VSS VDD \$5844 INV_X1
X$12483 \$4293 \$5674 \$5759 VDD VSS \$5842 HA_X1
X$12485 \$5925 VSS VDD \$5306 CLKBUF_X1
X$12487 \$5302 VSS VDD \$5674 INV_X1
X$12488 \$4643 \$5303 \$5301 VDD VSS \$5557 HA_X1
X$12490 \$5552 \$5301 \$5404 VDD VSS \$5660 HA_X1
X$12492 \$2886 VSS VDD \$5666 CLKBUF_X3
X$12493 \$5666 VSS VDD \$I101701 INV_X2
X$12494 \$5664 \$5597 VSS VDD \$5756 NAND2_X1
X$12495 \$5404 \$3692 VSS VDD \$5597 NAND2_X1
X$12496 \$5660 VSS VDD \$5664 INV_X1
X$12498 VSS \$4075 \$I100010 \$5547 \$5598 \$4734 VDD DFFR_X1
X$12499 \$5547 VSS VDD \$5292 CLKBUF_X1
X$12501 \$5549 VSS VDD \$5598 CLKBUF_X1
X$12502 \$5652 VSS VDD \$5651 CLKBUF_X1
X$12504 \$5928 VSS VDD \$5288 CLKBUF_X1
X$12505 \$5406 VSS VDD \$5094 CLKBUF_X1
X$12507 \$5533 VSS VDD \$5286 CLKBUF_X1
X$12508 \$5544 VSS VDD \$4076 CLKBUF_X1
X$12511 VSS \$5410 \$5212 \$4989 \$4738 \$5278 VDD FA_X1
X$12513 VSS \$5520 \$5278 \$5213 \$4990 \$5412 VDD FA_X1
X$12519 \$5651 VSS VDD \$5406 CLKBUF_X1
X$12521 \$5932 VSS VDD \$5544 CLKBUF_X1
X$12523 \$5763 VSS VDD \$5533 CLKBUF_X1
X$12525 VSS \$5409 \$4987 \$5410 \$4990 \$5643 VDD FA_X1
X$12530 \$5641 VSS VDD \$5412 INV_X1
X$12533 VSS \$5814 \$5641 \$5517 \$5635 \$5640 VDD FA_X1
X$12534 \$5519 VSS VDD \$5214 INV_X1
X$12537 \$5517 VSS VDD \$4992 INV_X1
X$12540 \$4085 \$2606 VSS VDD \$5766 OR2_X1
X$12542 \$5503 VSS VDD \$5215 INV_X1
X$12543 VSS \$5516 \$5519 \$5059 \$5502 \$5215 VDD FA_X1
X$12545 \$2606 \$2251 VSS VDD \$5503 NAND2_X1
X$12549 \$2609 \$4085 VSS VDD \$5635 NOR2_X1
X$12551 \$5415 VSS VDD \$I101751 INV_X4
X$12552 \$2886 VSS VDD \$5415 CLKBUF_X3
X$12557 \$2371 \$4085 VSS VDD \$5502 NOR2_X1
X$12558 \$2609 \$2251 VSS VDD \$5417 NAND2_X1
X$12559 \$5417 VSS VDD \$5419 INV_X1
X$12560 \$5418 VSS VDD \$4743 INV_X1
X$12565 VSS \$5630 \$4994 \$5418 \$5475 \$5419 VDD FA_X1
X$12567 \$5627 VSS VDD \$5630 INV_X1
X$12568 \$4380 \$2371 VSS VDD \$5627 NAND2_X1
X$12571 \$1904 \$4085 VSS VDD \$5475 NOR2_X1
X$12576 \$4734 VSS VDD \$3947 BUF_X1
X$12579 \$5621 VSS VDD \$5423 CLKBUF_X1
X$12580 \$5775 VSS VDD \$5621 CLKBUF_X1
X$12581 \$5415 VSS VDD \$5000 CLKBUF_X3
X$12582 \$6129 VSS VDD \$4312 CLKBUF_X1
X$12583 \$5246 VSS VDD \$5241 CLKBUF_X1
X$12584 VSS \$5000 \$I100323 \$1743 \$5451 \$3947 VDD DFFR_X1
X$12589 \$5616 VSS VDD \$5776 CLKBUF_X1
X$12590 \$5601 VSS VDD \$5616 CLKBUF_X1
X$12591 \$5602 VSS VDD \$5451 CLKBUF_X1
X$12594 \$5612 VSS VDD \$5604 CLKBUF_X1
X$12595 VSS \$5426 \$I99828 \$1904 \$5605 \$3947 VDD DFFR_X1
X$12596 \$5427 VSS VDD \$5605 CLKBUF_X1
X$12598 \$5777 VSS VDD \$5428 CLKBUF_X1
X$12601 \$5445 VSS VDD \$5220 CLKBUF_X1
X$12602 \$5791 VSS VDD \$5445 CLKBUF_X1
X$12603 VSS \$4552 \$I100334 \$1902 \$5431 \$3947 VDD DFFR_X1
X$12604 \$5429 VSS VDD \$5221 CLKBUF_X1
X$12612 VSS \$5426 \$I99881 \$5783 \$5949 \$3947 VDD DFFR_X1
X$12613 \$5609 VSS VDD \$5610 CLKBUF_X1
X$12614 \$5610 VSS VDD \$5431 CLKBUF_X1
X$12615 \$5782 VSS VDD \$5609 CLKBUF_X1
X$12631 \$19329 VSS VDD \$19332 INV_X1
X$12633 \$19334 \$19332 \$19292 VDD VSS \$19333 HA_X1
X$12634 \$19333 VSS VDD \$19331 INV_X1
X$12636 \$19331 \$19291 VSS VDD \$19389 NAND2_X1
X$12638 \$19292 \$19190 VSS VDD \$19291 NAND2_X1
X$12639 \$19292 VSS VDD \$19293 INV_X1
X$12641 \$19337 \$19191 \$19294 VDD VSS \$19346 HA_X1
X$12642 \$19346 \$19294 \$19340 VSS \$19390 VDD AOI21_X1
X$12643 \$19346 \$19430 \$19047 VSS \$19445 VDD AOI21_X1
X$12645 \$19340 \$19430 VSS VDD \$19493 XOR2_X1
X$12647 \$19389 \$19423 VDD VSS \$19515 XNOR2_X1
X$12651 \$19517 VSS VDD \$19562 INV_X1
X$12655 \$19294 VSS VDD \$19430 CLKBUF_X1
X$12661 \$19493 VSS VDD \$19392 CLKBUF_X1
X$12662 \$19391 VSS VDD \$19495 CLKBUF_X1
X$12664 VSS \$19295 \$I100261 \$19446 \$19392 \$15541 VDD DFFR_X1
X$12665 \$19363 VSS VDD \$19393 CLKBUF_X1
X$12666 VSS \$18905 \$I100480 \$19422 \$19394 \$15541 VDD DFFR_X1
X$12668 \$19495 VSS VDD \$19497 CLKBUF_X1
X$12669 \$19111 VSS VDD \$19496 CLKBUF_X1
X$12670 \$19496 VSS VDD \$19357 CLKBUF_X1
X$12671 \$19497 VSS VDD \$19110 CLKBUF_X1
X$12672 \$19575 VSS VDD \$19500 CLKBUF_X1
X$12673 \$19498 VSS VDD \$19504 CLKBUF_X1
X$12674 \$19297 VSS VDD \$19501 CLKBUF_X1
X$12675 \$19501 VSS VDD \$19426 CLKBUF_X1
X$12676 \$19393 VSS VDD \$19503 CLKBUF_X1
X$12677 \$19503 VSS VDD \$19194 CLKBUF_X1
X$12678 \$19426 VSS VDD \$19363 CLKBUF_X1
X$12679 \$19504 VSS VDD \$19578 CLKBUF_X1
X$12682 \$19508 VSS VDD \$19299 CLKBUF_X1
X$12684 VSS \$18905 \$I100301 \$18260 \$19370 \$15541 VDD DFFR_X1
X$12685 \$19374 \$19373 \$19116 VDD VSS \$19269 HA_X1
X$12688 \$19395 VSS VDD \$19448 CLKBUF_X1
X$12689 \$19366 VSS VDD \$19508 CLKBUF_X1
X$12690 \$19520 VSS VDD \$19370 CLKBUF_X1
X$12692 \$19422 VSS VDD \$19374 CLKBUF_X1
X$12696 \$19197 VSS VDD \$19582 INV_X1
X$12697 \$19197 \$19632 VDD VSS \$18414 XNOR2_X1
X$12700 \$19449 VSS VDD \$19371 INV_X1
X$12701 \$19052 \$19371 VDD VSS \$19373 XNOR2_X1
X$12704 \$19199 VSS VDD \$19494 INV_X1
X$12709 \$19449 \$19052 VSS VDD \$19450 NAND2_X1
X$12710 \$19494 \$19566 \$19449 VDD VSS \$19451 HA_X1
X$12713 \$19367 VSS VDD \$19118 CLKBUF_X1
X$12717 VSS \$19356 \$19414 \$19260 \$19409 \$19360 VDD FA_X1
X$12719 \$17010 \$18628 VSS VDD \$19397 NAND2_X1
X$12720 \$19397 VSS VDD \$19398 INV_X1
X$12723 \$19302 VSS VDD \$19258 INV_X1
X$12726 \$19491 VSS VDD \$19492 INV_X1
X$12727 VSS \$19488 \$19491 \$19480 \$19201 \$19361 VDD FA_X1
X$12728 \$19480 VSS VDD \$19360 INV_X1
X$12730 VSS \$19398 \$19488 \$19302 \$19411 \$19478 VDD FA_X1
X$12732 \$18804 \$15506 VDD VSS \$19478 AND2_X1
X$12733 \$18052 \$18093 VSS VDD \$19349 NAND2_X1
X$12734 \$19349 VSS VDD \$19411 INV_X1
X$12739 VSS \$19408 \$19550 \$19409 \$19326 \$19546 VDD FA_X1
X$12741 \$15506 \$18628 VSS VDD \$19399 NAND2_X1
X$12743 \$19399 VSS VDD \$19204 INV_X1
X$12744 \$19330 VSS VDD \$19408 INV_X1
X$12747 \$18260 \$17559 VSS VDD \$19400 NAND2_X1
X$12748 \$19400 VSS VDD \$19206 INV_X1
X$12749 \$19318 VSS VDD \$19326 INV_X1
X$12751 VSS \$19208 \$19407 \$19318 \$19321 \$19316 VDD FA_X1
X$12769 \$15506 \$18915 VSS VDD \$19454 NAND2_X1
X$12770 \$18041 \$18804 VSS VDD \$19617 NAND2_X1
X$12775 \$19407 VSS VDD \$19523 INV_X1
X$12779 \$18701 \$18093 VSS VDD \$19455 NOR2_X1
X$12781 \$18701 \$17559 VSS VDD \$19524 NOR2_X1
X$12782 \$18624 \$18093 VSS VDD \$19402 NAND2_X1
X$12783 \$19402 VSS VDD \$19458 INV_X1
X$12819 VSS \$13473 \$13088 \$13536 \$13004 \$13363 VDD FA_X1
X$12822 \$13692 VSS VDD \$13363 INV_X1
X$12824 \$13690 VSS VDD \$13811 INV_X1
X$12825 VSS \$13537 \$13473 \$14381 \$13533 \$13626 VDD FA_X1
X$12828 VSS \$13705 \$13690 \$13288 \$13474 \$13813 VDD FA_X1
X$12829 \$13546 VSS VDD \$13542 INV_X1
X$12830 VSS \$13542 \$13537 \$13544 \$13541 \$13288 VDD FA_X1
X$12832 \$13710 \$11561 VSS VDD \$13705 NAND2_X1
X$12833 \$13706 VSS VDD \$14430 INV_X1
X$12836 VSS \$13551 \$13546 \$13706 \$13555 \$13476 VDD FA_X1
X$12839 \$13628 VSS VDD \$13476 INV_X1
X$12843 \$13711 VSS VDD \$13712 INV_X1
X$12844 VSS \$13291 \$13711 \$13956 \$13559 \$13377 VDD FA_X1
X$12845 \$12525 \$8987 VSS VDD \$13555 NOR2_X1
X$12846 \$13292 VSS VDD \$13377 INV_X1
X$12849 \$12618 \$8987 VSS VDD \$13629 NAND2_X1
X$12851 \$12827 \$9658 VSS VDD \$13568 NAND2_X1
X$12852 \$13477 VSS VDD \$13576 INV_X1
X$12854 \$13568 VSS VDD \$13297 INV_X1
X$12858 \$12525 \$8455 VSS VDD \$13559 NOR2_X1
X$12860 \$13710 \$8455 VSS VDD \$13561 NAND2_X1
X$12862 VSS \$13721 \$13482 \$13477 \$13561 \$13629 VDD FA_X1
X$12863 \$13630 \$8444 VSS VDD \$13721 NAND2_X1
X$12865 \$13279 \$13297 \$13578 VDD VSS \$13575 HA_X1
X$12867 \$13484 VSS VDD \$13298 INV_X1
X$12869 VSS \$13578 \$13727 \$13299 \$13572 \$13138 VDD FA_X1
X$12870 \$13576 \$13299 \$13224 VDD VSS \$13631 HA_X1
X$12872 \$13633 VSS VDD \$13397 INV_X1
X$12877 \$13630 \$8455 VSS VDD \$13484 NAND2_X1
X$12880 \$13727 VSS VDD \$13732 INV_X1
X$12882 \$13631 VSS VDD \$13632 INV_X1
X$12884 \$13300 \$13414 \$13485 VDD VSS \$13582 HA_X1
X$12886 \$13301 VSS VDD \$13303 INV_X1
X$12887 \$13582 VSS VDD \$13304 INV_X1
X$12888 \$13486 \$13485 \$13410 VSS \$13816 VDD AOI21_X1
X$12890 \$13303 \$13095 \$13890 VSS VDD \$13595 NOR3_X1
X$12895 \$13589 \$13595 VSS VDD \$13487 NAND2_X1
X$12896 \$13306 \$13595 \$13600 VSS \$13488 VDD AOI21_X1
X$12901 \$13485 VSS VDD \$13301 CLKBUF_X1
X$12902 \$13486 \$13485 \$13155 VSS \$13634 VDD AOI21_X1
X$12903 \$13302 VSS VDD \$13637 INV_X1
X$12904 \$13582 VSS VDD \$13486 CLKBUF_X1
X$12906 \$13155 \$13303 VDD VSS \$13592 XNOR2_X1
X$12908 \$13741 VSS VDD \$13639 CLKBUF_X1
X$12909 VSS \$12464 \$I99801 \$13641 \$13639 \$12319 VDD DFFR_X1
X$12910 \$13487 \$13493 \$13488 VDD \$14687 VSS OAI21_X1
X$12913 \$13308 \$13309 VSS VDD \$13589 NOR2_X1
X$12914 \$13309 \$13493 \$13310 VDD \$13427 VSS OAI21_X1
X$12916 \$13427 \$13438 VDD VSS \$13751 XNOR2_X1
X$12919 \$13751 VSS VDD \$13819 CLKBUF_X1
X$12920 \$13313 VSS VDD \$13438 CLKBUF_X1
X$12921 \$13313 \$13321 \$13612 VSS VDD \$13314 NOR3_X1
X$12922 \$13318 \$13100 VSS VDD \$13309 NAND2_X1
X$12923 \$13100 VSS VDD \$13319 CLKBUF_X1
X$12924 \$13613 \$13492 VSS VDD \$13612 NAND2_X1
X$12925 \$13618 \$13490 \$13322 VDD \$13451 VSS OAI21_X1
X$12926 \$13318 VSS VDD \$13490 INV_X1
X$12927 \$13491 VSS VDD \$13618 INV_X1
X$12931 \$13624 VSS VDD \$13322 INV_X1
X$12932 \$13323 \$13651 \$13613 VDD VSS \$13624 HA_X1
X$12936 \$12532 VSS VDD \$I68801 INV_X1
X$12937 \$13319 VSS VDD \$13321 INV_X1
X$12938 \$12743 VSS VDD \$12532 CLKBUF_X3
X$12939 \$13759 \$13647 VDD VSS \$14096 XNOR2_X1
X$12941 \$13490 \$13648 \$13322 VDD \$13759 VSS OAI21_X1
X$12943 \$13491 \$13492 \$13315 VSS \$13648 VDD AOI21_X1
X$12945 \$13493 \$13318 VDD VSS \$13650 XNOR2_X1
X$12947 \$13491 \$13492 \$13769 VSS \$13493 VDD AOI21_X1
X$12949 \$13773 \$13653 \$13492 VDD VSS \$13491 HA_X1
X$12951 \$13325 VSS VDD \$13773 CLKBUF_X1
X$12956 \$13326 VSS VDD \$13496 CLKBUF_X1
X$12958 VSS \$13622 \$I100231 \$13497 \$13617 \$10386 VDD DFFR_X1
X$12959 VSS \$11440 \$I100193 \$13243 \$13500 \$10386 VDD DFFR_X1
X$12962 \$13780 VSS VDD \$13821 INV_X1
X$12965 \$13786 VSS VDD \$13788 INV_X1
X$12966 \$13656 \$13657 VSS VDD \$13655 NAND2_X1
X$12969 \$13791 VSS VDD \$13658 CLKBUF_X1
X$12972 \$13496 \$13660 \$13657 VDD VSS \$13794 HA_X1
X$12973 \$13794 VSS VDD \$13661 INV_X1
X$12976 \$13662 VSS VDD \$13932 INV_X1
X$12977 VSS \$11440 \$13944 \$13797 \$13799 \$10386 VDD DFFR_X1
X$12978 \$13242 VSS VDD \$13241 CLKBUF_X1
X$12979 \$13803 VSS VDD \$13499 CLKBUF_X1
X$12980 \$13497 VSS VDD \$13803 CLKBUF_X1
X$12982 VSS \$12961 \$13467 \$13940 \$13501 \$13330 VDD FA_X1
X$12983 \$13501 \$13467 VDD VSS \$13329 XNOR2_X1
X$12984 VSS \$13606 \$13931 \$13808 \$13501 \$13331 VDD FA_X1
X$12987 \$13332 VSS VDD \$13501 INV_X1
X$12988 VSS \$13103 \$13809 \$13332 \$13503 \$12844 VDD FA_X1
X$12989 VSS \$13103 \$13807 \$13594 \$13503 \$12632 VDD FA_X1
X$12990 \$13594 VSS VDD \$13506 INV_X1
X$12993 VSS \$13103 \$13507 \$13667 \$13503 \$13454 VDD FA_X1
X$12994 VSS \$11845 \$13800 \$13581 \$13503 \$13103 VDD FA_X1
X$12995 \$13581 VSS VDD \$13508 INV_X1
X$12998 \$9943 VSS VDD \$I101759 INV_X4
X$12999 VSS \$12424 \$13509 \$13511 \$11591 \$13442 VDD FA_X1
X$13003 \$14213 VSS VDD \$12542 CLKBUF_X1
X$13007 \$12963 \$13809 VDD VSS \$13928 XNOR2_X1
X$13010 \$13808 VSS VDD \$13831 INV_X1
X$13013 \$13664 VSS VDD \$13833 INV_X1
X$13015 \$13807 VSS VDD \$13915 INV_X1
X$13018 VSS \$13247 \$13665 \$13666 \$13504 \$13506 VDD FA_X1
X$13020 \$13507 VSS VDD \$13906 INV_X1
X$13023 \$13667 VSS VDD \$13591 INV_X1
X$13025 \$13800 VSS VDD \$13795 INV_X1
X$13028 VSS \$11589 \$13668 \$13790 \$12846 \$13508 VDD FA_X1
X$13029 VSS \$13509 \$13983 \$13510 \$13790 \$13447 VDD FA_X1
X$13030 \$13984 VSS VDD \$12639 CLKBUF_X1
X$13032 VSS \$13335 \$14053 \$13789 \$13511 \$13437 VDD FA_X1
X$13034 \$13789 VSS VDD \$13669 INV_X1
X$13036 VSS \$13512 \$13670 \$13782 \$13336 \$13428 VDD FA_X1
X$13038 \$13337 VSS VDD \$12797 CLKBUF_X1
X$13042 \$13670 VSS VDD \$13671 INV_X1
X$13045 \$13782 VSS VDD \$13672 INV_X1
X$13051 \$13342 \$13273 \$13776 VDD VSS \$13673 HA_X1
X$13052 \$13343 VSS VDD \$12495 CLKBUF_X1
X$13058 \$13345 VSS VDD \$13574 INV_X1
X$13061 \$13515 \$13571 VSS VDD \$13514 NAND2_X1
X$13065 \$13571 \$13678 VDD VSS \$13744 AND2_X1
X$13066 \$13566 VSS VDD \$13517 INV_X1
X$13070 VSS \$13514 \$13513 \$13516 \$13569 \$13675 VDD FA_X1
X$13072 \$13753 VSS VDD \$13677 INV_X1
X$13076 VSS \$13517 \$13753 \$13880 \$13747 \$13744 VDD FA_X1
X$13078 \$13515 \$13679 VSS VDD \$13566 NAND2_X1
X$13084 \$13678 \$13679 VSS VDD \$13518 NAND2_X1
X$13085 \$13518 VSS VDD \$13848 INV_X1
X$13089 \$13520 \$13680 \$13735 VDD VSS \$13728 HA_X1
X$13091 \$13347 VSS VDD \$13520 CLKBUF_X1
X$13092 \$13348 VSS VDD \$13349 INV_X1
X$13094 \$13521 VSS VDD \$13255 INV_X1
X$13097 \$13735 VSS VDD \$13348 CLKBUF_X1
X$13098 \$13349 \$13726 \$13350 VDD \$13682 VSS OAI21_X1
X$13100 \$13259 \$13349 \$13350 VDD \$13521 VSS OAI21_X1
X$13101 \$13352 VSS VDD \$13353 CLKBUF_X1
X$13104 \$13037 VSS VDD \$13118 CLKBUF_X3
X$13107 \$13356 \$13357 VDD VSS \$13532 XNOR2_X1
X$13110 \$13728 VSS VDD \$13350 INV_X1
X$13112 \$13349 VSS VDD \$13720 CLKBUF_X1
X$13113 \$13523 VSS VDD \$13726 INV_X1
X$13116 \$13523 \$13720 VDD VSS \$13713 XNOR2_X1
X$13119 \$10421 \$13115 VDD VSS \$13398 AND2_X1
X$13123 \$13702 VSS VDD \$13033 INV_X1
X$13125 \$13360 \$10421 VSS VDD \$13702 NAND2_X1
X$13126 \$13532 VSS VDD \$13699 CLKBUF_X1
X$13127 VSS \$13118 \$I100051 \$13360 \$13699 \$9850 VDD DFFR_X1
X$13128 VSS \$13118 \$I100180 \$13359 \$13358 \$9850 VDD DFFR_X1
X$13159 VSS \$13947 \$13692 \$13859 \$14005 \$13811 VDD FA_X1
X$13160 \$13859 VSS VDD \$13626 INV_X1
X$13163 \$13813 VSS VDD \$13948 INV_X1
X$13164 \$13474 VSS VDD \$13812 INV_X1
X$13172 VSS \$13947 \$13472 \$13362 \$14005 \$14007 VDD FA_X1
X$13173 \$6083 VSS VDD err[2] BUF_X1
X$13175 VSS \$13948 \$14007 \$12941 \$13812 \$13949 VDD FA_X1
X$13176 \$13630 \$11743 VSS VDD \$13813 NAND2_X1
X$13177 \$12618 \$11743 VSS VDD \$13474 NAND2_X1
X$13183 VSS \$13632 \$13965 \$13633 \$13815 \$13732 VDD FA_X1
X$13186 \$14182 \$13635 \$13968 \$13890 \$13637 VDD VSS \$13306 OAI221_X1
X$13187 \$13816 VSS VDD \$13892 CLKBUF_X1
X$13194 \$12523 \$9658 VSS VDD \$13953 NAND2_X1
X$13195 \$13953 VSS VDD \$14157 INV_X1
X$13196 \$14018 VSS VDD \$14306 INV_X1
X$13197 \$12525 \$8444 VSS VDD \$14308 NOR2_X1
X$13198 \$12450 \$8987 VSS VDD \$14018 NAND2_X1
X$13202 \$12450 \$8455 VSS VDD \$14086 NAND2_X1
X$13203 \$12523 \$8444 VSS VDD \$14088 NAND2_X1
X$13206 \$13958 \$8987 VSS VDD \$14389 NAND2_X1
X$13210 \$12827 \$10452 VSS VDD \$13959 NAND2_X1
X$13211 \$13959 VSS VDD \$14089 INV_X1
X$13212 \$13958 \$8444 VSS VDD \$14090 NAND2_X1
X$13215 \$13630 \$8987 VSS VDD \$13963 NAND2_X1
X$13216 \$12523 \$8455 VSS VDD \$14030 NAND2_X1
X$13218 \$13482 VSS VDD \$14320 INV_X1
X$13221 \$13964 VSS VDD \$13815 INV_X1
X$13225 \$13965 VSS VDD \$13966 INV_X1
X$13228 \$13967 VSS VDD \$14037 INV_X1
X$13229 \$14037 \$13634 \$14182 VDD \$14331 VSS OAI21_X1
X$13231 \$14236 \$13967 VSS VDD \$13890 NAND2_X1
X$13233 \$13892 \$13967 VDD VSS \$13969 XNOR2_X1
X$13236 VSS \$14238 \$I100159 \$13894 \$13592 \$12319 VDD DFFR_X1
X$13237 \$13894 VSS VDD \$13817 INV_X1
X$13238 \$13641 VSS VDD \$13898 INV_X1
X$13241 \$13817 \$13818 VSS VDD \$13414 NOR2_X2
X$13242 \$13817 \$14192 \$12954 \$13898 VSS VDD \$14049 NAND4_X1
X$13243 \$13898 \$13818 VSS VDD \$13098 NOR2_X2
X$13244 \$12954 \$13818 VSS VDD \$13041 NOR2_X2
X$13249 VSS \$12532 \$I100519 \$13901 \$13819 \$10386 VDD DFFR_X1
X$13251 \$13901 VSS VDD \$14098 INV_X1
X$13253 \$13321 VSS VDD \$13647 CLKBUF_X1
X$13260 \$13613 VSS VDD \$13318 CLKBUF_X1
X$13263 \$13315 \$13911 VSS VDD \$13908 XOR2_X1
X$13264 \$13492 VSS VDD \$13911 CLKBUF_X1
X$13270 \$13908 VSS VDD \$13973 CLKBUF_X1
X$13271 VSS \$12532 \$I99809 \$14103 \$13973 \$10386 VDD DFFR_X1
X$13273 \$13656 \$13792 VSS VDD \$13654 NAND2_X1
X$13274 \$13788 \$13654 VSS VDD \$13769 NAND2_X1
X$13275 \$13661 \$13821 \$13788 \$13655 \$13824 VDD VSS \$13315 OAI221_X1
X$13276 \$13656 VSS VDD \$13780 CLKBUF_X1
X$13277 \$13658 \$14625 \$13656 VDD VSS \$13786 HA_X1
X$13280 \$13821 VSS VDD \$14214 CLKBUF_X1
X$13281 \$13792 \$14214 VDD VSS \$14104 XNOR2_X1
X$13283 \$14063 \$13825 VDD VSS \$13975 XNOR2_X1
X$13284 \$13975 VSS VDD \$14061 CLKBUF_X1
X$13286 \$13657 VSS VDD \$13825 CLKBUF_X1
X$13288 \$13824 VSS VDD \$14063 CLKBUF_X1
X$13290 \$13798 \$13825 VSS VDD \$13922 NAND2_X1
X$13291 \$13922 \$13661 \$13925 VSS VDD \$13792 NAND3_X1
X$13292 \$13657 \$13929 \$13936 VSS VDD \$13925 NAND3_X1
X$13294 \$13933 VSS VDD \$13929 CLKBUF_X1
X$13295 \$13828 \$13932 \$13933 VDD VSS \$13798 HA_X1
X$13296 \$13797 VSS VDD \$13828 CLKBUF_X1
X$13297 \$13944 VSS VDD \$13829 CLKBUF_X1
X$13299 VSS \$14072 \$13824 \$14110 \$13662 \$13827 VDD FA_X1
X$13300 \$14109 VSS VDD \$13827 CLKBUF_X1
X$13301 \$13829 VSS VDD \$14109 CLKBUF_X1
X$13302 \$13936 VSS VDD \$14072 INV_X1
X$13305 VSS \$13622 \$I99853 \$14080 \$12937 \$10386 VDD DFFR_X1
X$13306 VSS \$13622 \$I100153 \$13663 \$14249 \$10386 VDD DFFR_X1
X$13310 \$13830 VSS VDD \$13244 CLKBUF_X1
X$13315 \$13465 \$13942 VDD VSS \$14112 XNOR2_X1
X$13317 VSS \$13940 \$13942 \$13980 \$13938 \$13931 VDD FA_X1
X$13318 \$13809 VSS VDD \$13938 INV_X1
X$13323 \$13928 \$14112 VDD VSS \$13979 XNOR2_X1
X$13324 \$13281 \$13979 VDD VSS \$14372 XNOR2_X1
X$13326 \$13980 VSS VDD \$14113 INV_X1
X$13328 VSS \$13665 \$13832 \$14066 \$13833 \$13915 VDD FA_X1
X$13329 VSS \$13502 \$14069 \$14210 \$13831 \$13809 VDD FA_X1
X$13334 VSS \$13914 \$13834 \$13905 \$13666 \$13906 VDD FA_X1
X$13338 VSS \$13668 \$13981 \$13982 \$13333 \$13795 VDD FA_X1
X$13343 \$13671 \$13669 \$14120 VDD VSS \$13835 HA_X1
X$13347 \$14066 VSS VDD \$14114 INV_X1
X$13348 \$13834 VSS VDD \$14115 INV_X1
X$13350 \$13905 VSS VDD \$14203 INV_X1
X$13353 \$13981 VSS VDD \$14206 INV_X1
X$13357 \$13982 VSS VDD \$14196 INV_X1
X$13359 \$13983 VSS VDD \$14197 INV_X1
X$13363 \$13510 VSS VDD \$14190 INV_X1
X$13364 \$14053 VSS VDD \$14117 INV_X1
X$13371 \$13835 VSS VDD \$14052 INV_X1
X$13373 \$14051 VSS VDD \$13337 CLKBUF_X1
X$13375 \$13339 \$13672 \$13900 VDD VSS \$13836 HA_X1
X$13382 \$13985 \$13837 \$13841 VSS \$14269 VDD AOI21_X1
X$13383 \$13896 VSS VDD \$13837 INV_X1
X$13386 \$13673 VSS VDD \$13838 INV_X1
X$13387 \$13776 \$13889 VSS VDD \$13896 NAND2_X1
X$13389 \$14185 \$13987 \$13838 VDD \$13985 VSS OAI21_X1
X$13390 \$13986 \$13987 \$13838 VDD \$14045 VSS OAI21_X1
X$13391 \$14628 VSS VDD \$14046 CLKBUF_X1
X$13392 \$13886 VSS VDD \$14040 INV_X1
X$13393 \$13884 \$13886 \$13889 VDD VSS \$14336 HA_X1
X$13394 \$13839 VSS VDD \$13884 INV_X1
X$13396 \$12644 \$13574 \$13840 VDD VSS \$13841 HA_X1
X$13399 \$13678 \$13989 VSS VDD \$13675 NAND2_X1
X$13400 VSS \$13516 \$13674 \$13882 \$13843 \$13677 VDD FA_X1
X$13401 \$13882 VSS VDD \$14034 INV_X1
X$13403 \$13776 VSS VDD \$13987 INV_X1
X$13404 VSS \$13839 \$13986 \$14038 \$14040 \$14181 VDD FA_X1
X$13405 \$13841 VSS VDD \$14181 INV_X1
X$13408 \$13843 \$14175 VDD VSS \$14125 XNOR2_X1
X$13410 VSS \$13881 \$14175 \$14032 \$14034 \$14126 VDD FA_X1
X$13411 \$13679 \$13844 VSS VDD \$13569 OR2_X1
X$13415 \$13846 VSS VDD \$13843 INV_X1
X$13418 \$13844 \$13872 VSS VDD \$13747 NOR2_X1
X$13419 VSS \$13873 \$13881 \$13845 \$13880 \$13846 VDD FA_X1
X$13421 VSS \$13847 \$13873 \$13849 \$13871 \$13848 VDD FA_X1
X$13425 \$13845 VSS VDD \$14128 INV_X1
X$13429 \$14273 \$13989 VSS VDD \$13990 NAND2_X1
X$13430 \$13990 VSS VDD \$14129 INV_X1
X$13432 \$14130 VSS VDD \$13847 INV_X1
X$13433 \$13515 \$13872 VSS VDD \$14130 NAND2_X1
X$13435 \$2886 VSS VDD \$13037 CLKBUF_X3
X$13436 \$13037 VSS VDD INV_X8
X$13437 \$13844 \$13680 VSS VDD \$13871 NOR2_X1
X$13443 VSS \$13995 \$I100003 \$14133 \$13140 \$9850 VDD DFFR_X1
X$13444 \$13852 \$13872 \$13997 VDD VSS \$13854 HA_X1
X$13445 \$13851 VSS VDD \$13852 CLKBUF_X1
X$13449 \$13854 \$13864 \$13682 VSS \$13853 VDD AOI21_X1
X$13452 \$13997 VSS VDD \$13864 CLKBUF_X1
X$13453 \$13854 \$13997 \$13681 VSS \$14134 VDD AOI21_X1
X$13454 \$13864 VSS VDD \$14017 INV_X1
X$13456 \$13681 \$14278 VDD VSS \$14155 XNOR2_X1
X$13458 \$14017 \$13349 \$14437 VSS VDD \$13999 NOR3_X1
X$13460 VSS \$13118 \$I99995 \$14140 \$14137 \$9850 VDD DFFR_X1
X$13461 \$13713 VSS VDD \$13855 CLKBUF_X1
X$13463 VSS \$14280 \$I100448 \$13856 \$13855 \$9850 VDD DFFR_X1
X$13474 \$14152 \$13115 \$13856 \$14140 VDD \$14003 VSS NOR4_X2
X$13476 \$14550 \$13999 \$14000 VSS \$14149 VDD AOI21_X1
X$13479 \$14015 \$13999 VSS VDD \$14013 NAND2_X1
X$13481 \$14013 \$12183 \$14149 VDD \$14012 VSS OAI21_X1
X$13487 \$13359 \$10421 VSS VDD \$14143 NAND2_X1
X$13490 VSS \$13266 \$14291 \$14003 \$10615 \$14714 VDD NAND4_X4
X$13635 xin[3] VSS VDD \$20024 BUF_X1
X$14436 VSS \$16449 \$I100443 \$17639 \$17849 \$15672 VDD DFFR_X1
X$14438 \$17640 VSS VDD \$17641 CLKBUF_X1
X$14439 \$17539 VSS VDD \$17371 CLKBUF_X1
X$14440 \$17641 VSS VDD \$17539 CLKBUF_X1
X$14452 \$17639 VSS VDD \$17685 CLKBUF_X1
X$14453 \$17685 VSS VDD \$17684 CLKBUF_X1
X$14454 \$17684 VSS VDD \$17640 CLKBUF_X1
X$14457 \$17540 VSS VDD \$17689 CLKBUF_X1
X$14458 \$17689 VSS VDD \$17687 CLKBUF_X1
X$14461 \$17687 VSS VDD \$17541 CLKBUF_X1
X$14464 \$17586 VSS VDD \$17697 CLKBUF_X1
X$14465 \$17696 VSS VDD \$17586 CLKBUF_X1
X$14466 \$17591 VSS VDD \$17696 CLKBUF_X1
X$14467 \$17597 VSS VDD \$17147 CLKBUF_X1
X$14468 \$17701 VSS VDD \$17592 CLKBUF_X1
X$14469 VSS \$17598 \$I100188 \$17644 \$17702 \$12319 VDD DFFR_X1
X$14470 VSS \$17598 \$I100536 \$17646 \$17543 \$15672 VDD DFFR_X1
X$14475 \$17925 VSS VDD \$17051 CLKBUF_X1
X$14476 \$17971 VSS VDD \$17702 CLKBUF_X1
X$14477 \$17697 VSS VDD \$17861 CLKBUF_X1
X$14478 \$17706 VSS VDD \$17049 CLKBUF_X1
X$14479 \$17644 VSS VDD \$17976 CLKBUF_X1
X$14480 \$17810 VSS VDD \$17712 CLKBUF_X1
X$14481 \$17243 VSS VDD \$17703 CLKBUF_X1
X$14482 \$17703 VSS VDD \$17701 CLKBUF_X1
X$14484 \$17712 VSS VDD \$17930 CLKBUF_X1
X$14485 \$17868 VSS VDD \$17811 CLKBUF_X1
X$14486 \$17812 VSS VDD \$17875 CLKBUF_X1
X$14487 \$17720 VSS VDD \$17813 CLKBUF_X1
X$14488 \$16864 VSS VDD \$17307 CLKBUF_X1
X$14489 VSS \$17598 \$I100030 \$17817 \$17645 \$15672 VDD DFFR_X1
X$14490 VSS \$16461 \$I100533 \$17819 \$17053 \$12319 VDD DFFR_X1
X$14491 \$2886 VSS VDD \$17110 CLKBUF_X3
X$14492 VSS \$17247 \$I100541 \$17735 \$17648 \$15672 VDD DFFR_X1
X$14496 VSS \$17247 \$17820 \$17888 \$17818 \$15672 VDD DFFR_X1
X$14498 \$17649 VSS VDD \$17648 CLKBUF_X1
X$14500 \$17884 \$15167 VSS VDD \$18131 NAND2_X1
X$14501 \$17733 VSS VDD \$17997 CLKBUF_X1
X$14505 \$17734 VSS VDD \$18005 INV_X1
X$14507 VSS \$17734 \$17754 \$17651 \$17739 \$17820 VDD FA_X1
X$14508 \$15458 \$14852 VSS VDD \$17545 NAND2_X1
X$14509 \$17545 VSS VDD \$18004 INV_X1
X$14510 \$15458 \$15168 VSS VDD \$17739 NAND2_X1
X$14512 \$17651 VSS VDD \$17741 INV_X1
X$14516 \$17735 VSS VDD \$17753 CLKBUF_X1
X$14517 VSS \$17741 \$17900 \$17914 \$17652 \$17484 VDD FA_X1
X$14518 \$15388 \$13414 VSS VDD \$17747 NAND2_X1
X$14521 \$17747 VSS VDD \$17628 INV_X1
X$14522 VSS \$17751 \$17652 \$17633 \$17745 \$17628 VDD FA_X1
X$14523 \$17627 VSS VDD \$17755 CLKBUF_X1
X$14526 \$17939 \$13181 VSS VDD \$17385 NAND2_X1
X$14527 \$17755 VSS VDD \$17759 CLKBUF_X1
X$14530 \$17752 VSS VDD \$17751 INV_X1
X$14533 \$17753 VSS VDD \$17760 CLKBUF_X1
X$14538 \$17633 \$18024 \$17249 VDD VSS \$17756 HA_X1
X$14541 VSS \$17756 \$18481 \$17548 \$18026 \$17914 VDD FA_X1
X$14542 \$17548 VSS VDD \$17636 INV_X1
X$14547 \$17759 VSS VDD \$17637 CLKBUF_X1
X$14549 \$17758 VSS VDD \$17654 INV_X1
X$14552 \$17549 VSS VDD \$17655 CLKBUF_X1
X$14553 \$2886 VSS VDD \$17365 CLKBUF_X3
X$14556 VSS \$17041 \$I100256 \$17770 \$17637 \$15541 VDD DFFR_X1
X$14558 \$17770 VSS VDD \$17774 CLKBUF_X1
X$14559 \$17774 VSS VDD \$17771 CLKBUF_X1
X$14560 \$17656 VSS VDD \$17775 CLKBUF_X1
X$14562 VSS \$17041 \$I100345 \$17781 \$17777 \$16907 VDD DFFR_X1
X$14568 VSS \$16885 \$17943 \$17549 \$17654 \$17760 VDD FA_X1
X$14569 VSS \$16886 \$I100129 \$17764 \$17655 \$15541 VDD DFFR_X1
X$14570 \$17764 VSS VDD \$17828 CLKBUF_X1
X$14573 \$18045 VSS VDD \$17367 CLKBUF_X1
X$14574 \$17771 VSS VDD \$17656 CLKBUF_X1
X$14575 VSS \$17077 \$17829 \$17517 \$17831 \$17924 VDD FA_X1
X$14576 \$17832 VSS VDD \$17777 CLKBUF_X1
X$14577 \$17775 VSS VDD \$17832 CLKBUF_X1
X$14578 VSS \$16886 \$I100061 \$17949 \$18415 \$15181 VDD DFFR_X1
X$14580 \$17781 VSS VDD \$18054 CLKBUF_X1
X$14581 \$17920 VSS VDD \$17658 CLKBUF_X1
X$14582 \$17917 VSS VDD \$17787 CLKBUF_X1
X$14583 \$17365 VSS VDD \$16890 CLKBUF_X3
X$14584 \$17787 VSS VDD \$17525 CLKBUF_X1
X$14587 VSS \$16890 \$I100137 \$17950 \$17916 \$16907 VDD DFFR_X1
X$14588 \$17553 VSS VDD \$17254 CLKBUF_X1
X$14592 \$17394 \$17239 VSS VDD \$17661 NAND2_X1
X$14596 \$17836 \$17661 VSS VDD \$17789 NAND2_X1
X$14597 \$17662 VSS VDD \$17836 INV_X1
X$14598 \$17792 \$17908 \$17394 VDD VSS \$17662 HA_X1
X$14599 \$17554 VSS VDD \$17792 INV_X1
X$14601 \$17907 VSS VDD \$17794 CLKBUF_X1
X$14603 \$17794 VSS VDD \$17904 CLKBUF_X1
X$14605 \$17555 VSS VDD \$17625 INV_X1
X$14611 \$17664 VSS VDD \$17556 INV_X1
X$14614 \$17806 VSS VDD \$17616 INV_X1
X$14615 \$17801 VSS VDD \$17617 INV_X1
X$14616 \$16335 \$17398 VSS VDD \$17806 NAND2_X1
X$14617 \$17797 VSS VDD \$17800 CLKBUF_X1
X$14618 \$17800 VSS VDD \$17260 CLKBUF_X1
X$14619 \$16672 \$17559 VSS VDD \$17801 NAND2_X1
X$14623 \$16144 \$17559 \$17611 VDD VSS \$17560 HA_X1
X$14626 \$17837 \$17895 \$17555 VDD VSS \$17901 HA_X1
X$14627 \$17796 VSS VDD \$17798 CLKBUF_X1
X$14628 \$17896 VSS VDD \$16480 CLKBUF_X1
X$14630 \$17663 VSS VDD \$16488 CLKBUF_X1
X$14631 VSS \$17802 \$17892 \$17664 \$17889 \$17887 VDD FA_X1
X$14633 \$17010 \$16677 VSS VDD \$17802 NAND2_X1
X$14634 \$17838 VSS VDD \$17797 CLKBUF_X1
X$14635 \$15506 \$17398 VSS VDD \$17887 NAND2_X1
X$14638 \$18446 VSS VDD \$17761 CLKBUF_X1
X$14640 \$17611 VSS VDD \$17668 CLKBUF_X1
X$14647 VSS \$19730 \$I100226 \$19920 \$19981 \$15672 VDD DFFR_X1
X$14648 VSS \$19730 \$I100279 \$13630 \$19870 \$15672 VDD DFFR_X1
X$14650 \$19886 VSS VDD \$19731 CLKBUF_X1
X$14651 \$19871 VSS VDD \$19886 CLKBUF_X1
X$14652 \$19940 VSS VDD \$19942 CLKBUF_X1
X$14653 \$19796 VSS VDD \$19888 CLKBUF_X1
X$14654 \$19888 VSS VDD \$19921 CLKBUF_X1
X$14655 \$19645 VSS VDD \$19889 CLKBUF_X1
X$14656 \$19889 VSS VDD \$19797 CLKBUF_X1
X$14657 VSS \$19730 \$I100257 \$19872 \$19946 \$15541 VDD DFFR_X1
X$14659 \$19799 VSS VDD \$19798 CLKBUF_X1
X$14660 \$19896 VSS VDD \$19799 CLKBUF_X1
X$14661 \$19924 VSS VDD \$19896 CLKBUF_X1
X$14664 \$16323 VSS VDD \$19898 CLKBUF_X1
X$14675 \$19823 VSS VDD \$19936 CLKBUF_X1
X$14676 \$19919 VSS VDD \$19938 CLKBUF_X1
X$14677 \$19920 VSS VDD \$19919 CLKBUF_X1
X$14679 \$19993 VSS VDD \$19870 CLKBUF_X1
X$14682 \$19730 VSS VDD \$I91531 CLKBUF_X1
X$14684 \$13630 VSS VDD \$19940 CLKBUF_X1
X$14685 \$19942 VSS VDD \$19871 CLKBUF_X1
X$14690 \$19921 VSS VDD \$19646 CLKBUF_X1
X$14692 \$19982 VSS VDD \$19946 CLKBUF_X1
X$14693 \$19922 VSS VDD \$19982 CLKBUF_X1
X$14694 \$19835 VSS VDD \$19922 CLKBUF_X1
X$14695 \$19949 VSS VDD \$19950 CLKBUF_X1
X$14696 \$19948 VSS VDD \$19949 CLKBUF_X1
X$14697 \$19872 VSS VDD \$19923 CLKBUF_X1
X$14698 \$19952 VSS VDD \$19924 CLKBUF_X1
X$14699 \$19923 VSS VDD \$19951 CLKBUF_X1
X$14700 \$19951 VSS VDD \$19952 CLKBUF_X1
X$14702 \$19898 VSS VDD \$19899 CLKBUF_X1
X$14705 \$19899 VSS VDD \$19801 CLKBUF_X1
X$14710 \$19900 VSS VDD \$19802 CLKBUF_X1
X$14716 \$19902 VSS VDD \$19903 CLKBUF_X1
X$14717 \$19873 VSS VDD \$19902 CLKBUF_X1
X$14718 \$19903 VSS VDD \$19904 CLKBUF_X1
X$14719 \$19904 VSS VDD \$19906 CLKBUF_X1
X$14721 \$19907 VSS VDD \$19805 CLKBUF_X1
X$14722 \$19906 VSS VDD \$19907 CLKBUF_X1
X$14724 \$19804 VSS VDD \$19908 CLKBUF_X1
X$14725 \$19908 VSS VDD \$19954 CLKBUF_X1
X$14726 \$19911 VSS VDD \$19909 CLKBUF_X1
X$14727 \$19909 VSS VDD \$19874 CLKBUF_X1
X$14728 \$19875 VSS VDD \$19806 CLKBUF_X1
X$14729 \$19913 VSS VDD \$19875 CLKBUF_X1
X$14730 \$19806 VSS VDD \$19735 CLKBUF_X1
X$14735 \$19954 VSS VDD \$19958 CLKBUF_X1
X$14736 \$19958 VSS VDD \$19959 CLKBUF_X1
X$14737 \$19874 VSS VDD \$19913 CLKBUF_X1
X$14740 \$19734 VSS VDD \$19844 CLKBUF_X1
X$14741 \$19847 VSS VDD \$19918 CLKBUF_X1
X$14742 \$19918 VSS VDD \$19963 CLKBUF_X1
X$14743 \$19916 VSS VDD \$19650 CLKBUF_X1
X$14744 VSS \$19651 \$I100170 \$19925 \$19965 \$15541 VDD DFFR_X1
X$14746 \$19926 VSS VDD \$19910 INV_X1
X$14747 \$19910 VSS VDD \$19857 CLKBUF_X1
X$14749 \$19959 VSS VDD \$19961 CLKBUF_X1
X$14751 \$19961 VSS VDD \$19965 CLKBUF_X1
X$14752 \$19807 VSS VDD \$19962 CLKBUF_X1
X$14753 \$19962 VSS VDD \$19967 CLKBUF_X1
X$14754 \$19963 VSS VDD \$19916 CLKBUF_X1
X$14755 \$19736 VSS VDD \$19652 CLKBUF_X1
X$14757 \$19925 VSS VDD \$19926 CLKBUF_X1
X$14759 \$19876 VSS VDD \$19738 CLKBUF_X1
X$14765 \$19741 \$19808 VDD VSS \$19856 XNOR2_X1
X$14766 \$19895 \$19897 VSS VDD \$19877 NAND2_X1
X$14767 \$19877 \$19842 VDD VSS \$16262 XNOR2_X1
X$14768 \$19808 \$19741 \$19887 VDD \$19842 VSS OAI21_X1
X$14769 \$19878 VSS VDD \$19808 INV_X1
X$14772 \$19927 VSS VDD \$19887 INV_X1
X$14776 \$19975 \$19983 \$19878 VDD VSS \$19927 HA_X1
X$14777 \$19928 VSS VDD \$19975 INV_X1
X$14778 VSS \$19657 \$19928 \$19781 \$19884 \$19809 VDD FA_X1
X$14783 \$19879 \$19998 VDD VSS \$19743 XNOR2_X1
X$14791 \$19973 \$19977 VDD VSS \$20010 XNOR2_X1
X$14793 VSS \$19361 \$19977 \$20001 \$19201 \$19882 VDD FA_X1
X$14794 VSS \$19361 \$19978 \$19883 \$19201 \$19810 VDD FA_X1
X$14815 \$19978 VSS VDD \$19997 INV_X1
X$14816 \$19883 VSS VDD \$19953 INV_X1
X$14819 VSS \$19944 \$19985 \$19884 \$19933 \$19953 VDD FA_X1
X$14821 \$19990 VSS VDD \$19988 INV_X1
X$14824 \$19814 VSS VDD \$19929 INV_X1
X$14825 VSS \$19612 \$19986 \$19931 \$19816 \$19811 VDD FA_X1
X$14826 \$19931 VSS VDD \$19933 INV_X1
X$14873 VSS \$9560 \$I100081 \$11120 \$10868 \$8875 VDD DFFR_X1
X$14874 \$6180 VSS VDD \$9560 CLKBUF_X3
X$14875 \$9560 VSS VDD \$I94060 CLKBUF_X1
X$14877 \$10440 VSS VDD \$10532 INV_X1
X$14878 VSS \$9560 \$I100472 \$10531 \$10626 \$8875 VDD DFFR_X1
X$14879 \$9425 \$10452 \$10368 VDD VSS \$10370 HA_X1
X$14880 \$10535 \$10368 \$10038 VSS \$10790 VDD AOI21_X1
X$14883 \$10366 VSS VDD \$10529 CLKBUF_X1
X$14884 \$10884 VSS VDD \$10882 CLKBUF_X1
X$14885 \$10531 VSS VDD \$10530 CLKBUF_X1
X$14886 \$10890 VSS VDD \$10631 CLKBUF_X1
X$14887 \$10631 \$10788 VDD VSS \$10632 XNOR2_X1
X$14888 \$10368 VSS VDD \$10447 INV_X1
X$14889 \$10535 \$10368 \$10369 VSS \$10890 VDD AOI21_X1
X$14890 \$10370 VSS VDD \$10535 CLKBUF_X1
X$14892 \$10038 \$10447 VDD VSS \$10791 XNOR2_X1
X$14895 VSS \$9099 \$I99993 \$10541 \$10904 \$8875 VDD DFFR_X1
X$14896 \$10636 VSS VDD \$10538 CLKBUF_X1
X$14898 VSS \$9099 \$I100243 \$10374 \$10538 \$8875 VDD DFFR_X1
X$14899 \$7826 \$10374 VDD VSS \$9658 AND2_X1
X$14903 \$7826 \$10541 VDD VSS \$10452 AND2_X1
X$14905 \$10541 \$10913 \$10375 \$10374 VSS VDD \$10921 NOR4_X1
X$14907 \$10052 \$7826 VSS VDD \$12090 NAND2_X1
X$14911 \$10543 \$9689 \$8230 \$10921 VSS VDD \$10794 NAND4_X1
X$14925 \$3618 VSS VDD \$3503 CLKBUF_X1
X$14927 \$3556 VSS VDD \$3621 CLKBUF_X1
X$14928 \$3657 VSS VDD \$3319 CLKBUF_X1
X$14929 VSS \$3244 \$I100398 \$3622 \$3752 \$1304 VDD DFFR_X1
X$14930 \$3668 VSS VDD \$3662 CLKBUF_X1
X$14931 \$3622 VSS VDD \$3507 CLKBUF_X1
X$14933 \$3796 VSS VDD \$3504 CLKBUF_X1
X$14934 \$3621 VSS VDD \$3959 CLKBUF_X1
X$14935 \$3957 VSS VDD \$3801 CLKBUF_X1
X$14936 \$3006 VSS VDD \$1304 BUF_X2
X$14937 VSS \$3244 \$I99949 \$3802 \$3801 \$1304 VDD DFFR_X1
X$14939 \$3802 VSS VDD \$3508 CLKBUF_X1
X$14940 \$4142 VSS VDD \$3670 CLKBUF_X1
X$14941 \$4139 VSS VDD \$3562 CLKBUF_X1
X$14943 \$3509 VSS VDD \$3248 CLKBUF_X1
X$14944 \$3676 VSS VDD \$4357 CLKBUF_X1
X$14945 \$3806 VSS VDD \$3512 CLKBUF_X1
X$14947 VSS \$3244 \$I99935 \$3807 \$4138 \$1304 VDD DFFR_X1
X$14948 \$3512 VSS VDD \$3676 CLKBUF_X1
X$14949 \$3807 VSS VDD \$3806 CLKBUF_X1
X$14950 \$3681 VSS VDD \$3346 CLKBUF_X1
X$14951 \$3515 VSS VDD \$3811 CLKBUF_X1
X$14952 \$3514 VSS VDD \$3681 CLKBUF_X1
X$14953 VSS \$3074 \$I100528 \$3690 \$3624 \$1304 VDD DFFR_X1
X$14955 \$3687 VSS VDD \$3625 CLKBUF_X1
X$14956 \$3626 VSS VDD \$3688 CLKBUF_X1
X$14957 \$3690 VSS VDD \$3355 CLKBUF_X1
X$14960 \$3694 VSS VDD \$3695 CLKBUF_X1
X$14961 \$3697 VSS VDD \$3575 CLKBUF_X1
X$14962 \$3574 VSS VDD \$3697 CLKBUF_X1
X$14963 VSS \$3628 \$I100525 \$3703 \$3699 \$3833 VDD DFFR_X1
X$14965 \$4000 VSS VDD \$3828 CLKBUF_X1
X$14966 \$3837 \$3379 VDD VSS \$4396 XNOR2_X1
X$14968 \$3379 VSS VDD \$3255 INV_X1
X$14969 \$3629 VSS VDD \$4006 CLKBUF_X1
X$14972 \$4147 VSS VDD \$3909 CLKBUF_X1
X$14973 \$3809 VSS VDD \$3624 CLKBUF_X1
X$14974 \$3811 VSS VDD \$3809 CLKBUF_X1
X$14975 \$3688 VSS VDD \$3687 CLKBUF_X1
X$14976 \$3625 VSS VDD \$3818 CLKBUF_X1
X$14977 \$1692 VSS VDD \$3074 CLKBUF_X3
X$14978 VSS \$3074 \$I100012 \$4165 \$3818 \$3006 VDD DFFR_X1
X$14979 VSS \$3628 \$I100150 \$3993 \$3827 \$3833 VDD DFFR_X1
X$14980 \$3828 VSS VDD \$4001 CLKBUF_X1
X$14981 \$3703 VSS VDD \$3919 CLKBUF_X1
X$14982 \$3834 VSS VDD \$3835 CLKBUF_X1
X$14983 VSS \$3628 \$I100001 \$3629 \$3835 \$3833 VDD DFFR_X1
X$14984 VSS \$3758 \$3837 \$3921 \$3845 \$3757 VDD FA_X1
X$14985 \$3518 VSS VDD \$3845 INV_X1
X$14987 \$3373 VSS VDD \$3757 INV_X1
X$14988 \$3758 VSS VDD \$3519 INV_X1
X$14994 \$3853 \$4014 \$4017 VDD VSS \$3373 HA_X1
X$14995 \$3854 VSS VDD \$4014 INV_X1
X$14996 VSS \$3713 \$3758 \$3854 \$3855 \$3852 VDD FA_X1
X$14999 \$3522 VSS VDD \$3713 INV_X1
X$15004 \$3521 VSS VDD \$3852 INV_X1
X$15007 \$3630 \$3719 VSS VDD \$3759 NAND2_X1
X$15008 \$3161 \$3585 \$4018 VDD VSS \$3522 HA_X1
X$15012 \$3858 VSS VDD \$3857 INV_X1
X$15014 \$3857 \$3759 VSS VDD \$3853 NAND2_X1
X$15015 \$3863 \$4018 \$3630 VDD VSS \$3858 HA_X1
X$15017 \$2588 \$4021 \$3864 VDD VSS \$3863 AND3_X1
X$15018 \$3162 \$3591 \$3864 VDD VSS \$3719 HA_X1
X$15022 \$3010 VSS VDD \$3721 CLKBUF_X1
X$15030 \$3523 VSS VDD \$4025 CLKBUF_X1
X$15032 \$4028 VSS VDD \$3418 INV_X1
X$15033 \$3165 VSS VDD \$3111 CLKBUF_X1
X$15034 \$3924 VSS VDD \$3164 INV_X1
X$15036 \$3011 VSS VDD \$1984 CLKBUF_X1
X$15037 \$3730 \$3731 VSS VDD \$2586 NAND2_X1
X$15039 \$3730 \$3731 VSS VDD \$3526 NOR2_X1
X$15042 \$20 \$3770 \$3736 VSS VDD \$584 NOR3_X1
X$15044 \$3633 VSS VDD \$3527 INV_X1
X$15046 \$3762 VSS VDD \$3876 CLKBUF_X1
X$15047 \$3873 \$3730 \$3418 VDD \$3763 VSS OAI21_X1
X$15048 \$3767 VSS VDD \$3873 INV_X1
X$15049 \$3876 VSS VDD \$3730 INV_X1
X$15050 \$3767 \$3770 \$3762 VDD \$3525 VSS OAI21_X1
X$15051 \$3769 \$3771 VSS VDD \$3770 NOR2_X1
X$15053 \$4024 \$3771 VSS VDD \$3772 NAND2_X1
X$15054 \$3772 VSS VDD \$3633 CLKBUF_X1
X$15055 \$3527 VSS VDD \$3736 CLKBUF_X1
X$15057 \$584 VSS VDD \$3429 CLKBUF_X1
X$15059 \$3167 VSS VDD \$4225 CLKBUF_X1
X$15060 \$3743 VSS VDD \$3746 CLKBUF_X1
X$15061 \$3529 VSS VDD \$3743 CLKBUF_X1
X$15062 \$3748 VSS VDD \$3269 CLKBUF_X1
X$15063 \$3746 VSS VDD \$3268 CLKBUF_X1
X$15064 \$3168 VSS VDD \$3748 CLKBUF_X1
X$15065 \$3634 VSS VDD \$3773 CLKBUF_X1
X$15071 \$3528 VSS VDD \$4059 CLKBUF_X1
X$15073 VSS \$2347 \$I99970 \$4012 \$3773 \$45 VDD DFFR_X1
X$15075 \$3894 VSS VDD \$3929 CLKBUF_X1
X$15078 \$3017 VSS VDD \$4061 CLKBUF_X1
X$15079 \$2877 VSS VDD \$4463 CLKBUF_X1
X$15083 VSS \$3744 \$3900 \$3531 \$3735 \$3742 VDD FA_X1
X$15084 \$3223 VSS VDD \$3744 INV_X1
X$15087 \$2756 \$940 VSS VDD \$3612 NAND2_X1
X$15091 \$3900 VSS VDD \$3930 INV_X1
X$15094 \$3222 VSS VDD \$4466 INV_X1
X$15097 \$2752 VSS VDD \$4241 CLKBUF_X1
X$15098 \$3221 VSS VDD \$4063 INV_X1
X$15099 \$3902 VSS VDD \$4064 INV_X1
X$15100 VSS \$3896 \$3902 \$3931 \$3170 \$4008 VDD FA_X1
X$15102 \$4066 VSS VDD \$3022 CLKBUF_X1
X$15105 \$3888 VSS VDD \$3609 CLKBUF_X1
X$15106 \$3637 VSS VDD \$3896 INV_X1
X$15108 VSS \$3717 \$3636 \$3724 \$3727 \$3533 VDD FA_X1
X$15109 \$3724 VSS VDD \$3604 INV_X1
X$15110 \$2972 \$1494 VSS VDD \$3638 NAND2_X1
X$15111 \$3638 VSS VDD \$3717 INV_X1
X$15115 \$1611 \$2359 VSS VDD \$3933 NAND2_X1
X$15118 \$2057 \$2184 VSS VDD \$3885 NAND2_X1
X$15120 \$3884 VSS VDD \$3888 CLKBUF_X1
X$15121 \$3885 VSS VDD \$3727 INV_X1
X$15123 \$3534 VSS VDD \$3533 INV_X1
X$15126 \$3642 \$1321 VSS VDD \$3534 NAND2_X1
X$15130 VSS \$3881 \$4067 \$3934 \$3882 \$3779 VDD FA_X1
X$15131 \$2057 \$2759 VSS VDD \$3882 NAND2_X1
X$15133 \$3642 \$2184 VSS VDD \$3779 NAND2_X1
X$15134 \$2972 \$2359 VSS VDD \$3881 NAND2_X1
X$15137 \$3536 VSS VDD \$3642 INV_X1
X$15140 \$3180 \$2359 VSS VDD \$3647 NAND2_X1
X$15141 \$3647 VSS VDD \$3578 INV_X1
X$15142 \$3031 \$3292 \$3648 VDD VSS \$3692 HA_X1
X$15148 \$2057 \$3032 VSS VDD \$3781 NAND2_X1
X$15149 \$3781 VSS VDD \$4215 INV_X1
X$15150 \$3865 VSS VDD \$3498 CLKBUF_X1
X$15151 \$1855 \$2759 VSS VDD \$3783 NAND2_X1
X$15152 \$3783 VSS VDD \$3935 INV_X1
X$15155 \$3642 \$2759 VSS VDD \$3937 NAND2_X1
X$15159 \$3648 \$3642 \$3032 VSS VDD \$4641 NAND3_X1
X$15162 \$726 VSS VDD \$3844 CLKBUF_X1
X$15169 \$3840 \$4296 VDD VSS \$539 XNOR2_X1
X$15171 \$3539 \$3826 \$3938 VDD \$3840 VSS OAI21_X1
X$15175 \$3650 \$3649 \$3203 VSS \$3826 VDD AOI21_X1
X$15178 \$3650 VSS VDD \$3540 INV_X1
X$15183 \$3788 \$4079 \$3649 VDD VSS \$3650 HA_X1
X$15185 \$3789 VSS VDD \$3788 INV_X1
X$15187 \$3939 VSS VDD \$3541 INV_X1
X$15191 VSS \$3675 \$3408 \$3542 \$3682 \$3678 VDD FA_X1
X$15192 \$3825 VSS VDD \$3678 INV_X1
X$15196 VSS \$3038 \$3825 \$3820 \$3065 \$3941 VDD FA_X1
X$15198 VSS \$3978 \$3675 \$3406 \$3805 \$3543 VDD FA_X1
X$15201 \$3820 VSS VDD \$3543 INV_X1
X$15204 \$2609 \$1764 VSS VDD \$4405 NAND2_X1
X$15206 \$3791 VSS VDD \$3942 INV_X1
X$15208 \$2606 \$1743 VSS VDD \$3791 NAND2_X1
X$15210 \$2886 VSS VDD \$750 CLKBUF_X3
X$15211 \$750 VSS VDD \$I101765 INV_X4
X$15216 \$3973 VSS VDD \$3970 INV_X1
X$15219 \$2606 \$2084 VSS VDD \$3803 NAND2_X1
X$15220 VSS \$3944 \$3546 \$3041 \$3803 \$4551 VDD FA_X1
X$15223 \$3792 VSS VDD \$3374 INV_X1
X$15228 \$1735 \$2251 VSS VDD \$3661 NAND2_X1
X$15229 \$3661 VSS VDD \$3660 INV_X1
X$15230 \$3660 \$3793 \$3559 VDD VSS \$3548 HA_X1
X$15236 \$3963 VSS VDD \$3793 INV_X1
X$15239 VSS \$3799 \$I100093 \$3948 \$3800 \$3947 VDD DFFR_X1
X$15240 \$3652 VSS VDD \$3552 CLKBUF_X1
X$15242 \$4099 VSS VDD \$3549 CLKBUF_X1
X$15245 VSS \$3799 \$I100054 \$3952 \$3549 \$3947 VDD DFFR_X1
X$15246 \$4110 VSS VDD \$3656 CLKBUF_X1
X$15248 \$3655 VSS VDD \$3653 CLKBUF_X1
X$15249 \$3654 VSS VDD \$3550 CLKBUF_X1
X$15259 VSS \$3794 \$I100048 \$1739 \$3550 \$3947 VDD DFFR_X1
X$15281 \$232 \$231 VDD VSS \$320 XNOR2_X1
X$15295 \$614 \$611 \$573 VSS \$481 VDD AOI21_X1
X$15296 \$487 \$486 \$611 VDD VSS \$614 HA_X1
X$15298 \$299 VSS VDD \$486 INV_X1
X$15300 \$490 VSS VDD \$298 INV_X1
X$15301 VSS \$437 \$490 \$438 \$436 \$417 VDD FA_X1
X$15302 VSS \$337 \$328 \$496 \$500 \$497 VDD FA_X1
X$15306 \$612 VSS VDD \$487 INV_X1
X$15308 VSS \$574 \$612 \$972 \$496 \$575 VDD FA_X1
X$15311 \$619 VSS VDD \$575 INV_X1
X$15313 \$622 VSS VDD \$576 INV_X1
X$15314 VSS \$437 \$619 \$622 \$436 \$627 VDD FA_X1
X$15315 \$438 VSS VDD \$497 INV_X1
X$15316 \$630 VSS VDD \$627 INV_X1
X$15319 VSS \$626 \$630 \$754 \$524 \$504 VDD FA_X1
X$15320 VSS \$511 \$417 \$267 \$632 \$266 VDD FA_X1
X$15322 VSS \$514 \$337 \$344 \$234 \$422 VDD FA_X1
X$15323 \$169 \$527 VSS VDD \$511 NOR2_X1
X$15325 \$386 VSS VDD \$301 INV_X1
X$15327 \$632 VSS VDD \$504 INV_X1
X$15330 \$578 \$759 VSS VDD \$632 NOR2_X1
X$15333 \$301 \$428 VSS VDD \$577 NOR2_X1
X$15336 \$527 \$578 VSS VDD \$420 OR2_X1
X$15340 VSS \$444 \$514 \$580 \$647 \$430 VDD FA_X1
X$15341 \$385 \$153 VSS VDD \$430 NAND2_X1
X$15342 \$385 VSS VDD \$197 INV_X1
X$15343 \$386 \$43 VSS VDD \$444 NAND2_X1
X$15344 \$201 \$263 VSS VDD \$524 NAND2_X1
X$15346 \$527 VSS VDD \$263 INV_X1
X$15348 \$886 \$33 VSS VDD \$647 NAND2_X1
X$15350 \$385 \$263 VSS VDD \$1133 NAND2_X1
X$15352 VSS \$589 \$718 \$385 \$535 \$45 VDD DFFR_X1
X$15354 \$203 VSS VDD \$362 CLKBUF_X1
X$15355 \$306 VSS VDD \$365 CLKBUF_X1
X$15357 \$533 VSS VDD \$664 CLKBUF_X1
X$15359 \$386 \$263 VSS VDD \$925 NAND2_X1
X$15360 \$583 \$584 VSS VDD \$626 NAND2_X1
X$15361 \$784 VSS VDD \$585 CLKBUF_X1
X$15364 \$786 VSS VDD \$583 INV_X1
X$15365 \$385 VSS VDD \$662 CLKBUF_X1
X$15366 \$662 VSS VDD \$588 CLKBUF_X1
X$15367 \$540 VSS VDD \$535 CLKBUF_X1
X$15368 \$588 VSS VDD \$533 CLKBUF_X1
X$15369 \$794 VSS VDD \$788 CLKBUF_X1
X$15371 \$664 VSS VDD \$667 CLKBUF_X1
X$15372 VSS \$589 \$I100176 \$448 \$390 \$45 VDD DFFR_X1
X$15375 VSS \$77 \$I100463 \$380 \$547 \$85 VDD DFFR_X1
X$15376 \$681 VSS VDD \$546 CLKBUF_X1
X$15377 \$549 VSS VDD \$547 CLKBUF_X1
X$15378 VSS \$720 \$I100321 \$384 \$551 \$85 VDD DFFR_X1
X$15380 \$561 VSS VDD \$453 CLKBUF_X1
X$15381 \$452 \$451 VSS VDD \$592 NAND2_X1
X$15382 \$454 VSS VDD \$392 INV_X1
X$15383 \$105 VSS VDD \$702 CLKBUF_X1
X$15387 \$667 VSS VDD \$390 CLKBUF_X1
X$15389 \$669 VSS VDD \$540 CLKBUF_X1
X$15393 \$672 VSS VDD \$669 CLKBUF_X1
X$15394 \$678 VSS VDD \$808 CLKBUF_X1
X$15396 \$380 VSS VDD \$678 CLKBUF_X1
X$15397 \$546 VSS VDD \$672 CLKBUF_X1
X$15398 VSS \$720 \$I99980 \$449 \$680 \$85 VDD DFFR_X1
X$15399 \$591 \$688 VSS VDD \$451 NAND2_X1
X$15400 \$685 VSS VDD \$549 CLKBUF_X1
X$15401 \$820 VSS VDD \$551 CLKBUF_X1
X$15402 \$696 VSS VDD \$685 CLKBUF_X1
X$15403 \$703 \$450 VSS VDD \$701 NAND2_X2
X$15404 \$451 \$452 \$454 VSS VDD \$450 NAND3_X1
X$15405 \$710 VSS VDD \$812 CLKBUF_X1
X$15407 \$392 \$592 VSS VDD \$703 NAND2_X1
X$15408 \$724 VSS VDD \$710 CLKBUF_X1
X$15410 \$802 VSS VDD \$561 CLKBUF_X1
X$15412 \$695 VSS VDD \$696 CLKBUF_X1
X$15413 VSS \$725 \$I99943 \$798 \$684 \$85 VDD DFFR_X1
X$15414 \$566 VSS VDD \$695 CLKBUF_X1
X$15416 VSS \$725 \$I100278 \$690 \$938 \$85 VDD DFFR_X1
X$15419 VSS \$274 \$457 \$595 \$539 \$85 VDD DFFR_X1
X$15420 \$393 \$458 \$176 VDD VSS \$174 HA_X1
X$15422 \$404 \$311 VSS VDD \$563 NOR2_X1
X$15423 \$274 VSS VDD \$I94445 CLKBUF_X1
X$15424 \$1130 VSS VDD \$274 CLKBUF_X3
X$15425 \$397 VSS VDD \$311 INV_X1
X$15427 \$690 VSS VDD \$566 CLKBUF_X1
X$15432 \$594 \$1171 \$397 VSS VDD \$454 NAND3_X2
X$15434 \$457 VSS VDD \$273 CLKBUF_X1
X$15435 \$310 VSS VDD \$596 CLKBUF_X1
X$15436 \$595 VSS VDD \$675 CLKBUF_X1
X$15437 \$675 VSS VDD \$393 CLKBUF_X1
X$15438 \$596 VSS VDD \$459 CLKBUF_X1
X$15439 \$563 VSS VDD \$458 BUF_X1
X$15441 \$421 VSS VDD \$350 CLKBUF_X1
X$15446 \$243 \$462 \$313 \$275 VSS VDD \$418 NAND4_X1
X$15447 \$243 \$275 VSS VDD \$404 NOR2_X2
X$15448 \$338 \$418 \$598 VDD VSS \$280 HA_X1
X$15449 \$403 \$404 VSS VDD \$314 NAND2_X1
X$15450 \$463 \$335 VSS VDD \$658 NAND2_X1
X$15451 \$462 VSS VDD \$315 INV_X1
X$15456 \$598 \$462 VSS VDD \$594 NOR2_X1
X$15458 \$598 VSS VDD \$395 INV_X1
X$15461 \$338 VSS VDD \$655 INV_X1
X$15462 \$655 \$403 \$404 VSS VDD \$463 NAND3_X1
X$15463 \$658 \$649 VSS \$397 VDD NAND2_X4
X$15464 \$729 \$651 VSS VDD \$649 NAND2_X2
X$15465 \$537 \$330 VSS VDD \$651 NOR2_X2
X$15467 \$406 \$276 VSS VDD \$465 NOR2_X1
X$15468 VSS \$464 \$I100258 \$406 \$520 \$327 VDD DFFR_X1
X$15469 \$466 \$395 \$397 VSS VDD \$471 NAND3_X1
X$15471 \$397 \$468 \$395 VDD VSS \$414 AND3_X1
X$15472 \$415 VSS VDD \$324 CLKBUF_X1
X$15473 \$469 VSS VDD \$415 CLKBUF_X1
X$15474 \$506 \$414 \$601 VDD VSS \$408 HA_X1
X$15475 VSS \$503 \$470 \$473 \$471 \$491 VDD FA_X1
X$15476 \$493 VSS VDD \$485 CLKBUF_X1
X$15478 \$477 VSS VDD \$475 CLKBUF_X1
X$15479 VSS \$476 \$409 \$317 \$747 \$327 VDD DFFR_X1
X$15492 VSS \$464 \$I100094 \$777 \$638 \$327 VDD DFFR_X1
X$15493 \$600 \$465 VSS VDD \$537 NAND2_X1
X$15494 \$406 VSS VDD \$466 CLKBUF_X1
X$15497 \$276 VSS VDD \$468 CLKBUF_X1
X$15498 \$316 VSS VDD \$520 CLKBUF_X1
X$15500 \$601 VSS VDD \$469 CLKBUF_X1
X$15502 \$408 VSS VDD \$503 INV_X1
X$15503 \$470 VSS VDD \$634 CLKBUF_X1
X$15504 \$634 \$602 VDD VSS \$769 XNOR2_X1
X$15506 \$602 \$485 \$408 VSS VDD \$761 NAND3_X1
X$15507 \$411 \$602 VSS VDD \$760 NAND2_X1
X$15508 \$478 VSS VDD \$506 CLKBUF_X1
X$15510 \$473 VSS VDD \$474 CLKBUF_X1
X$15511 \$475 VSS VDD \$491 CLKBUF_X1
X$15512 \$609 VSS VDD \$478 CLKBUF_X1
X$15513 \$409 VSS VDD \$477 CLKBUF_X1
X$15514 \$605 VSS VDD \$609 CLKBUF_X1
X$15515 VSS \$476 \$I100021 \$605 \$607 \$327 VDD DFFR_X1
X$15545 \$18942 VSS VDD \$18639 CLKBUF_X1
X$15556 \$13015 VSS VDD \$18719 CLKBUF_X1
X$15560 VSS \$18899 \$I99937 \$18774 \$16943 \$15672 VDD DFFR_X1
X$15562 \$18598 VSS VDD \$18677 CLKBUF_X1
X$15564 \$18469 VSS VDD \$18646 CLKBUF_X1
X$15565 \$18677 VSS VDD \$18642 CLKBUF_X1
X$15569 VSS \$18472 \$18678 \$18832 \$18721 \$18599 VDD FA_X1
X$15573 VSS \$18603 \$19184 \$18680 \$18541 \$18602 VDD FA_X1
X$15576 \$18775 VSS VDD \$18721 INV_X1
X$15577 \$18471 \$18837 VDD VSS \$18776 XNOR2_X1
X$15578 \$18832 VSS VDD \$18777 INV_X1
X$15580 VSS \$18600 \$18836 \$18950 \$18273 \$18775 VDD FA_X1
X$15584 VSS \$18400 \$18903 \$18602 \$18476 \$18959 VDD FA_X1
X$15585 \$18476 VSS VDD \$18779 INV_X1
X$15587 VSS \$18606 \$18957 \$18964 \$18681 \$18779 VDD FA_X1
X$15588 \$18604 VSS VDD \$18681 INV_X1
X$15590 \$18605 VSS VDD \$18734 CLKBUF_X1
X$15601 \$11109 VSS VDD \$I69249 INV_X1
X$15602 \$6180 VSS VDD \$11109 CLKBUF_X3
X$15603 \$11933 VSS VDD \$11742 CLKBUF_X1
X$15604 VSS \$11109 \$I100411 \$11414 \$11797 \$8875 VDD DFFR_X1
X$15606 \$11034 \$11743 \$11413 VDD VSS \$11873 HA_X1
X$15608 \$11563 \$11631 \$11746 VDD \$11745 VSS OAI21_X1
X$15609 \$11940 VSS VDD \$11746 INV_X1
X$15611 \$11873 \$11564 VSS VDD \$11748 NAND2_X1
X$15612 \$11748 \$11811 \$11640 VSS VDD \$11820 NAND3_X1
X$15613 \$11749 VSS VDD \$11811 INV_X1
X$15622 \$11929 VSS VDD \$11872 CLKBUF_X1
X$15623 \$11935 VSS VDD \$12032 CLKBUF_X1
X$15624 \$11872 VSS VDD \$11935 CLKBUF_X1
X$15625 \$11742 VSS VDD \$11929 CLKBUF_X1
X$15626 \$11560 VSS VDD \$11933 CLKBUF_X1
X$15630 \$11564 VSS VDD \$12080 INV_X1
X$15631 \$11873 VSS VDD \$11940 CLKBUF_X1
X$15632 \$11745 \$12080 VDD VSS \$12082 XNOR2_X1
X$15634 VSS \$11751 \$I100039 \$11421 \$12084 \$8875 VDD DFFR_X1
X$15636 VSS \$11743 \$11306 \$11420 \$11750 VDD AOI21_X4
X$15638 \$11654 VSS VDD \$11750 INV_X1
X$15639 \$11820 \$11655 VDD VSS \$11875 XNOR2_X1
X$15641 VSS \$11751 \$11566 \$11654 \$11752 \$8875 VDD DFFR_X1
X$15646 \$11875 VSS VDD \$11752 CLKBUF_X1
X$15647 \$12140 VSS VDD \$11308 CLKBUF_X1
X$15650 \$11425 VSS VDD \$11656 CLKBUF_X1
X$15655 \$11567 \$11831 \$11830 VDD \$11754 VSS OAI21_X1
X$15656 \$11754 \$10795 VDD VSS \$11833 XNOR2_X1
X$15658 \$11756 \$11155 \$11876 VDD VSS \$11755 HA_X1
X$15659 \$11757 VSS VDD \$11756 INV_X1
X$15663 \$6518 VSS VDD \$11952 INV_X1
X$15666 \$11876 VSS VDD \$12040 INV_X1
X$15667 \$11755 \$11876 \$11877 VSS \$11831 VDD AOI21_X1
X$15668 \$11755 VSS VDD \$12041 INV_X1
X$15672 \$11878 VSS VDD \$12099 INV_X1
X$15675 VSS \$11963 \$12042 \$12104 \$11962 \$11758 VDD FA_X1
X$15677 \$11568 VSS VDD \$11758 INV_X1
X$15681 VSS \$11879 \$11963 \$12043 \$10805 \$11966 VDD FA_X1
X$15682 \$11759 VSS VDD \$11966 INV_X1
X$15687 \$11570 VSS VDD \$12044 INV_X1
X$15689 VSS \$10945 \$12208 \$11760 \$11431 \$11683 VDD FA_X1
X$15697 VSS \$11881 \$12045 \$12109 \$11760 \$11880 VDD FA_X1
X$15700 VSS \$11971 \$12242 \$12111 \$11573 \$11882 VDD FA_X1
X$15702 \$11761 VSS VDD \$11882 INV_X1
X$15705 \$11846 VSS VDD \$11971 INV_X1
X$15707 VSS \$11434 \$11846 \$11969 \$11433 \$11762 VDD FA_X1
X$15710 VSS \$11435 \$11883 \$12113 \$11692 \$11763 VDD FA_X1
X$15714 \$11969 VSS VDD \$11970 INV_X1
X$15716 \$11574 VSS VDD \$12046 INV_X1
X$15719 VSS \$11698 \$11884 \$11764 \$11322 \$11854 VDD FA_X1
X$15721 \$11703 \$11856 \$11885 VDD VSS \$11854 HA_X1
X$15725 \$11885 VSS VDD \$12218 INV_X1
X$15728 \$11765 VSS VDD \$12217 INV_X1
X$15729 \$12357 VSS VDD \$11066 CLKBUF_X1
X$15730 \$12361 VSS VDD \$11577 CLKBUF_X1
X$15732 \$11888 VSS VDD \$11438 CLKBUF_X1
X$15733 \$11437 \$11436 \$11978 VDD VSS \$11765 HA_X1
X$15734 \$11704 VSS VDD \$11886 INV_X1
X$15737 \$11327 \$11984 \$11864 VDD VSS \$11988 HA_X1
X$15738 \$11864 \$11329 VSS VDD \$11990 NAND2_X1
X$15740 \$11978 \$11983 \$11984 VDD VSS \$12118 HA_X1
X$15741 \$11328 \$11889 \$11983 VDD VSS \$12120 HA_X1
X$15744 \$12543 VSS VDD \$11071 CLKBUF_X1
X$15745 \$11891 \$11990 VSS VDD \$11989 NAND2_X1
X$15746 \$11988 VSS VDD \$11891 INV_X1
X$15749 \$11578 VSS VDD \$11581 CLKBUF_X1
X$15751 \$11582 VSS VDD \$11583 CLKBUF_X1
X$15755 \$8317 \$10571 VSS VDD \$11768 NAND2_X1
X$15756 \$11768 VSS VDD \$11996 INV_X1
X$15762 VSS \$11995 \$12845 \$12128 \$11997 \$11996 VDD FA_X1
X$15763 \$11770 VSS VDD \$11995 INV_X1
X$15764 \$9773 \$8636 VSS VDD \$11770 NAND2_X1
X$15766 \$10571 \$8636 VSS VDD \$11772 NAND2_X1
X$15767 \$11772 VSS VDD \$11858 INV_X1
X$15768 VSS \$11855 \$11773 \$11893 \$11861 \$11858 VDD FA_X1
X$15770 \$8636 \$11074 VSS VDD \$11776 NAND2_X1
X$15771 VSS \$11588 \$11845 \$11844 \$11894 \$11778 VDD FA_X1
X$15773 \$11844 VSS VDD \$11725 INV_X1
X$15778 \$9308 \$11074 VSS VDD \$11780 NAND2_X1
X$15781 \$11780 VSS VDD \$11827 INV_X1
X$15782 VSS \$11596 \$12794 \$11782 \$11827 \$12011 VDD FA_X1
X$15786 \$9133 \$10835 VSS VDD \$11997 NOR2_X1
X$15788 \$11773 VSS VDD \$12154 INV_X1
X$15790 \$11893 VSS VDD \$12048 INV_X1
X$15792 \$11776 VSS VDD \$11894 INV_X1
X$15794 \$8633 \$10578 VSS VDD \$11896 NAND2_X1
X$15795 \$11896 VSS VDD \$11778 INV_X1
X$15798 \$9773 \$9308 VSS VDD \$12008 NAND2_X1
X$15801 \$12012 VSS VDD \$12053 INV_X1
X$15802 \$12008 VSS VDD \$11900 INV_X1
X$15805 \$10571 \$8144 VSS VDD \$11899 NAND2_X1
X$15806 \$11899 VSS VDD \$12056 INV_X1
X$15810 \$7354 \$11584 VSS VDD \$11904 NAND2_X1
X$15811 \$12017 VSS VDD \$10735 CLKBUF_X1
X$15812 \$11904 VSS VDD \$12057 INV_X1
X$15816 \$12013 VSS VDD \$12011 INV_X1
X$15819 \$10490 \$7354 VSS VDD \$12058 NAND2_X1
X$15820 \$10490 \$8144 VSS VDD \$11906 NAND2_X1
X$15821 \$11906 VSS VDD \$12059 INV_X1
X$15823 \$11784 \$12059 \$12061 VDD VSS \$12062 HA_X1
X$15824 \$10836 \$7354 VSS VDD \$11783 NAND2_X1
X$15826 \$11783 VSS VDD \$11784 INV_X1
X$15832 \$11822 VSS VDD \$12196 INV_X1
X$15833 VSS \$12000 \$12001 \$12571 \$11909 \$11682 VDD FA_X1
X$15835 \$11599 \$11822 VDD VSS \$11910 XNOR2_X1
X$15836 VSS \$11679 \$11785 \$11913 \$11909 \$11815 VDD FA_X1
X$15840 VSS \$11601 \$11987 \$11912 \$11603 \$11602 VDD FA_X1
X$15843 VSS \$11347 \$11973 \$11808 \$10250 \$10411 VDD FA_X1
X$15844 \$11808 VSS VDD \$11605 INV_X1
X$15848 \$11807 \$11606 \$11919 VDD VSS \$11918 HA_X1
X$15853 \$11912 VSS VDD \$11909 INV_X1
X$15856 \$11913 VSS VDD \$12063 INV_X1
X$15859 VSS \$11343 \$11991 \$12110 \$11090 \$11912 VDD FA_X1
X$15861 \$11513 VSS VDD \$12064 INV_X1
X$15864 VSS \$11604 \$11976 \$12096 \$11915 \$12066 VDD FA_X1
X$15867 \$11973 VSS VDD \$12067 INV_X1
X$15870 \$11917 VSS VDD \$12068 INV_X1
X$15872 \$12069 \$11919 VSS VDD \$11957 NAND2_X1
X$15873 \$11918 \$11919 \$11500 VSS \$11922 VDD AOI21_X1
X$15875 \$11957 VSS VDD \$11923 INV_X1
X$15877 \$11923 \$11949 VSS VDD \$12079 NAND2_X1
X$15880 \$11951 \$11919 VSS VDD \$12071 XOR2_X1
X$15883 VSS \$11790 \$I99921 \$11942 \$11469 \$9850 VDD DFFR_X1
X$15884 \$11476 \$11787 VSS VDD \$12299 NAND2_X1
X$15885 \$11621 VSS VDD \$11472 INV_X1
X$15886 \$11471 \$11353 VSS VDD \$11787 NAND2_X1
X$15887 \$11353 \$11789 VDD VSS \$11928 XNOR2_X1
X$15889 VSS \$11790 \$I100181 \$11611 \$11932 \$9850 VDD DFFR_X1
X$15897 \$11942 VSS VDD \$12072 CLKBUF_X1
X$15900 \$11472 VSS VDD \$11789 CLKBUF_X1
X$15903 \$11928 VSS VDD \$11932 CLKBUF_X1
X$15941 \$6519 VSS VDD yout[7] BUF_X1
X$15947 \$5565 VSS VDD yout[6] BUF_X1
X$15948 \$6268 VSS VDD yout[4] BUF_X1
X$15952 \$6276 VSS VDD yout[2] BUF_X1
X$15955 VSS \$12574 \$12607 \$12673 \$12576 \$12608 VDD FA_X1
X$15956 \$12450 \$11561 VSS VDD \$12574 NAND2_X1
X$15957 \$12523 \$11743 VSS VDD \$12608 NAND2_X1
X$15961 \$11561 \$12523 VDD VSS \$12609 AND2_X1
X$15962 \$11303 \$12525 VSS VDD \$12576 OR2_X1
X$15963 \$12450 \$11303 VSS VDD \$12611 NAND2_X1
X$15966 \$12187 VSS VDD \$12293 CLKBUF_X1
X$15970 \$12525 \$9658 VSS VDD \$12683 NOR2_X1
X$15972 \$12453 VSS VDD \$12391 CLKBUF_X1
X$15974 \$12230 VSS VDD \$12453 CLKBUF_X1
X$15975 \$12391 VSS VDD \$12033 CLKBUF_X1
X$15976 \$12136 VSS VDD \$12452 CLKBUF_X1
X$15977 \$12452 VSS VDD \$12300 CLKBUF_X1
X$15980 \$12454 VSS VDD \$12392 CLKBUF_X1
X$15981 \$12232 VSS VDD \$12454 CLKBUF_X1
X$15982 \$12392 VSS VDD \$12034 CLKBUF_X1
X$15983 \$12137 VSS VDD \$12456 CLKBUF_X1
X$15984 \$12456 VSS VDD \$12306 CLKBUF_X1
X$15987 \$12450 \$10452 VSS VDD \$12527 NAND2_X1
X$15988 \$12527 VSS VDD \$12614 INV_X1
X$15992 \$12090 \$12691 \$12616 VSS VDD \$12588 NOR3_X1
X$15993 \$12461 VSS VDD \$12457 CLKBUF_X1
X$15994 \$12457 VSS VDD \$12459 CLKBUF_X1
X$15995 \$12459 VSS VDD \$12037 CLKBUF_X1
X$15996 \$12139 VSS VDD \$12463 CLKBUF_X1
X$15997 \$12463 VSS VDD \$12312 CLKBUF_X1
X$16002 \$12588 \$12617 \$12692 VDD VSS \$12529 HA_X1
X$16003 \$12692 \$12618 \$8455 VSS VDD \$12589 NAND3_X1
X$16005 \$12589 VSS VDD \$12707 INV_X1
X$16007 \$12619 \$12529 VSS VDD \$12592 NAND2_X1
X$16008 \$12707 \$12833 \$12619 VDD VSS \$12711 HA_X1
X$16010 \$12711 VSS VDD \$12709 INV_X1
X$16013 VSS \$12464 \$I100227 \$12394 \$12141 \$12319 VDD DFFR_X1
X$16015 \$12395 VSS VDD \$12201 INV_X1
X$16016 \$12395 \$12143 VDD VSS \$12530 XNOR2_X1
X$16019 \$12234 \$12205 \$12470 VSS \$12395 VDD AOI21_X1
X$16020 \$12236 \$12205 VSS VDD \$12533 XOR2_X1
X$16026 VSS \$12464 \$I99964 \$12717 \$12714 \$12319 VDD DFFR_X1
X$16028 VSS \$12464 \$I99981 \$12620 \$12530 \$12319 VDD DFFR_X1
X$16031 VSS \$12532 \$I99979 \$12955 \$12533 \$12319 VDD DFFR_X1
X$16032 VSS \$12600 \$I99983 \$13045 \$12724 \$12319 VDD DFFR_X1
X$16033 \$12238 VSS VDD \$12479 INV_X1
X$16034 \$12239 \$12238 VDD VSS \$12724 XNOR2_X1
X$16035 \$12479 \$12239 \$12396 VDD \$12470 VSS OAI21_X1
X$16036 \$12481 VSS VDD \$12396 INV_X1
X$16039 \$12398 \$12601 \$12396 \$12483 VSS VDD \$12236 NAND4_X1
X$16040 \$12400 \$12238 VSS VDD \$12398 NAND2_X1
X$16041 \$12238 \$12399 VSS VDD \$12486 NAND2_X1
X$16042 \$12400 \$12399 \$12491 VSS \$12239 VDD AOI21_X1
X$16045 \$12735 \$12399 VSS VDD \$12956 XOR2_X1
X$16051 \$12486 VSS VDD \$12401 INV_X1
X$16053 \$12404 \$12402 VSS VDD \$12491 NAND2_X1
X$16055 \$12243 VSS VDD \$12403 INV_X1
X$16059 \$12401 \$12731 VSS VDD \$12601 NAND2_X1
X$16061 \$12401 \$12243 \$12536 \$12730 VSS VDD \$12483 NAND4_X1
X$16062 \$12243 \$12622 VSS VDD \$12402 NAND2_X1
X$16063 \$12733 \$12403 \$12404 VDD \$12731 VSS OAI21_X1
X$16064 \$12403 \$12738 \$12404 VDD \$12735 VSS OAI21_X1
X$16067 \$12405 VSS VDD \$12404 INV_X1
X$16070 \$12406 \$12245 \$12536 VDD VSS \$12741 HA_X1
X$16074 \$12741 \$12536 \$12730 VSS \$12738 VDD AOI21_X1
X$16075 \$12741 VSS VDD \$12733 INV_X1
X$16077 \$12246 \$12147 \$12407 VDD VSS \$12408 HA_X1
X$16082 \$12502 VSS VDD \$12409 INV_X1
X$16083 \$12410 VSS VDD \$12357 CLKBUF_X1
X$16085 VSS \$12509 \$12629 \$12414 \$12250 \$12252 VDD FA_X1
X$16086 \$10835 \$8633 VSS VDD \$12509 OR2_X1
X$16087 \$8317 \$10835 VSS VDD \$12779 NOR2_X1
X$16088 \$12254 VSS VDD \$12585 INV_X1
X$16093 \$12538 VSS VDD \$12149 CLKBUF_X1
X$16094 \$12408 VSS VDD \$12755 INV_X1
X$16096 \$12539 VSS VDD \$12626 INV_X1
X$16100 \$12768 VSS VDD \$12762 INV_X1
X$16101 VSS \$12541 \$12539 \$12768 \$12409 \$12586 VDD FA_X1
X$16103 \$12120 VSS VDD \$12586 INV_X1
X$16106 \$12542 VSS VDD \$12543 CLKBUF_X1
X$16110 \$12250 VSS VDD \$12777 INV_X1
X$16113 VSS \$12585 \$12584 \$12630 \$12779 \$12777 VDD FA_X1
X$16114 VSS \$12417 \$12416 \$12418 \$12375 \$12513 VDD FA_X1
X$16116 \$8636 \$10835 VSS VDD \$12375 NOR2_X1
X$16117 \$10147 \$11074 VSS VDD \$12787 NAND2_X1
X$16118 VSS \$12421 \$12419 \$12380 \$12420 \$12257 VDD FA_X1
X$16119 \$8633 \$11074 VSS VDD \$12421 NAND2_X1
X$16121 \$8317 \$11074 VSS VDD \$12793 NAND2_X1
X$16124 \$12416 VSS VDD \$12631 INV_X1
X$16127 \$12787 VSS VDD \$12583 INV_X1
X$16128 \$12419 VSS VDD \$12632 INV_X1
X$16129 \$12257 VSS VDD \$12633 INV_X1
X$16131 \$12420 VSS VDD \$12634 INV_X1
X$16133 \$12793 VSS VDD \$12792 INV_X1
X$16134 \$12259 VSS VDD \$12920 INV_X1
X$16136 VSS \$11737 \$12635 \$12846 \$12048 \$12798 VDD FA_X1
X$16137 \$10147 \$10490 VSS VDD \$13079 NAND2_X1
X$16139 \$10147 \$10836 VSS VDD \$12919 NAND2_X1
X$16147 \$8633 \$10490 VSS VDD \$12801 NAND2_X1
X$16149 \$12814 VSS VDD \$11280 CLKBUF_X1
X$16150 \$8633 \$10836 VSS VDD \$12810 NAND2_X1
X$16151 \$8317 \$10490 VSS VDD \$12546 NAND2_X1
X$16152 \$12546 VSS VDD \$12817 INV_X1
X$16154 \$12504 VSS VDD \$12424 INV_X1
X$16158 \$11593 \$12210 \$12500 VDD VSS \$12425 HA_X1
X$16162 \$8317 \$10836 VSS VDD \$12579 NAND2_X1
X$16170 \$8636 \$10490 VSS VDD \$12548 NAND2_X1
X$16172 \$12548 VSS VDD \$12802 INV_X1
X$16174 \$12797 VSS VDD \$11297 CLKBUF_X1
X$16177 \$12549 VSS VDD \$12640 INV_X1
X$16180 \$8636 \$10836 VSS VDD \$12497 NAND2_X1
X$16182 \$12495 VSS VDD \$11299 CLKBUF_X1
X$16183 \$12428 \$12496 \$12465 VDD VSS \$12781 HA_X1
X$16186 \$12497 VSS VDD \$12578 INV_X1
X$16187 \$12791 VSS VDD \$12786 INV_X1
X$16189 \$12578 \$12786 \$12783 VDD VSS \$12785 HA_X1
X$16191 \$12783 VSS VDD \$12577 INV_X1
X$16193 \$12275 \$12551 \$12466 VDD VSS \$12429 HA_X1
X$16194 \$12273 \$12274 \$12467 VDD VSS \$12550 HA_X1
X$16195 \$12466 \$12166 VSS VDD \$12552 NAND2_X1
X$16199 VSS \$12167 \$12430 \$12431 \$12553 \$12001 VDD FA_X1
X$16203 \$12432 VSS VDD \$12553 INV_X1
X$16204 VSS \$11991 \$12646 \$12555 \$12063 \$12432 VDD FA_X1
X$16205 \$9245 VSS VDD \$I101762 INV_X4
X$16211 \$12550 VSS VDD \$12641 INV_X1
X$16213 \$12465 \$12910 \$12551 VDD VSS \$12642 HA_X1
X$16214 \$12643 \$12552 VSS VDD \$12644 NAND2_X1
X$16215 \$12429 VSS VDD \$12643 INV_X1
X$16218 \$12553 \$12430 VDD VSS \$12554 XNOR2_X1
X$16219 \$12554 \$11910 VDD VSS \$13108 XNOR2_X1
X$16220 VSS \$12571 \$12972 \$12645 \$12553 \$11785 VDD FA_X1
X$16224 \$2886 VSS VDD \$9245 CLKBUF_X3
X$16228 \$12555 VSS VDD \$12906 INV_X1
X$16229 \$12278 VSS VDD \$12728 INV_X1
X$16233 \$12444 VSS VDD \$12440 INV_X1
X$16234 VSS \$11976 \$12726 \$12444 \$12434 \$12443 VDD FA_X1
X$16237 \$12726 VSS VDD \$12647 INV_X1
X$16241 \$12438 \$12440 \$12556 VDD VSS \$12436 HA_X1
X$16247 \$12436 \$12556 \$12563 VSS \$12648 VDD AOI21_X1
X$16248 \$12436 \$12556 \$12086 VSS \$12557 VDD AOI21_X1
X$16249 \$12086 \$12556 VSS VDD \$12696 XOR2_X1
X$16252 VSS \$12860 \$I99990 \$12690 \$12696 \$9850 VDD DFFR_X1
X$16253 VSS \$13118 \$I99987 \$12650 \$12174 \$9850 VDD DFFR_X1
X$16257 \$12181 VSS VDD \$12675 INV_X1
X$16258 \$12303 VSS VDD \$12559 CLKBUF_X1
X$16260 \$12181 \$12176 \$11926 VSS \$12659 VDD AOI21_X1
X$16263 \$12290 VSS VDD \$12281 CLKBUF_X1
X$16282 VSS \$11109 \$I100415 \$12078 \$12032 \$8875 VDD DFFR_X1
X$16288 \$5381 VSS VDD yout[5] BUF_X1
X$16290 \$11952 VSS VDD yout[0] BUF_X1
X$16293 \$6698 VSS VDD yout[1] BUF_X1
X$16297 \$12186 VSS VDD \$12226 CLKBUF_X1
X$16298 \$12294 VSS VDD \$12187 CLKBUF_X1
X$16299 \$12226 VSS VDD \$12294 CLKBUF_X1
X$16301 \$12078 VSS VDD \$12186 CLKBUF_X1
X$16303 \$12033 VSS VDD \$12136 CLKBUF_X1
X$16306 \$12293 VSS VDD \$12228 CLKBUF_X1
X$16307 VSS \$11751 \$I100131 \$12230 \$12228 \$8875 VDD DFFR_X1
X$16308 VSS \$11751 \$I100065 \$12232 \$12300 \$8875 VDD DFFR_X1
X$16309 \$12082 VSS VDD \$12084 CLKBUF_X1
X$16313 \$12034 VSS VDD \$12137 CLKBUF_X1
X$16316 \$11751 VSS VDD \$I94019 CLKBUF_X1
X$16317 \$6180 VSS VDD \$11751 CLKBUF_X3
X$16319 \$12090 VSS VDD \$8455 INV_X1
X$16320 \$12037 VSS VDD \$12139 CLKBUF_X1
X$16324 \$12197 \$11567 VDD VSS \$12141 XNOR2_X1
X$16327 \$12040 \$12097 \$12041 VDD \$12197 VSS OAI21_X1
X$16329 \$12103 \$12143 \$12201 VSS \$12097 VDD AOI21_X1
X$16330 \$12105 \$12099 \$12143 VDD VSS \$12103 HA_X1
X$16331 \$12042 VSS VDD \$12105 INV_X1
X$16334 \$12104 VSS VDD \$12235 INV_X1
X$16337 VSS \$11751 \$I99967 \$12461 \$12306 \$8875 VDD DFFR_X1
X$16339 VSS \$11751 \$I100122 \$12140 \$12312 \$8875 VDD DFFR_X1
X$16341 \$11877 \$12040 VDD VSS \$12714 XNOR2_X1
X$16346 \$12323 \$12142 \$12321 VDD \$11877 VSS OAI21_X1
X$16347 \$12143 VSS VDD \$12323 INV_X1
X$16348 \$12103 VSS VDD \$12321 INV_X1
X$16353 \$12234 \$12205 \$12236 VSS \$12142 VDD AOI21_X1
X$16354 \$12337 \$12235 \$12205 VDD VSS \$12234 HA_X1
X$16356 \$12207 VSS VDD \$12337 INV_X1
X$16359 VSS \$12208 \$12207 \$12237 \$12043 \$12044 VDD FA_X1
X$16361 \$12045 VSS VDD \$12240 INV_X1
X$16368 \$12237 VSS VDD \$12342 INV_X1
X$16370 \$12240 \$12342 \$12238 VDD VSS \$12481 HA_X1
X$16373 \$12241 \$12344 \$12399 VDD VSS \$12400 HA_X1
X$16375 \$12109 VSS VDD \$12344 INV_X1
X$16377 \$12111 VSS VDD \$12244 INV_X1
X$16381 \$11883 VSS VDD \$12146 INV_X1
X$16384 VSS \$12216 \$12406 \$12147 \$12113 \$11884 VDD FA_X1
X$16385 \$11764 \$11700 \$12148 VDD VSS \$12216 HA_X1
X$16388 \$12242 VSS VDD \$12241 INV_X1
X$16390 \$12213 \$12244 \$12243 VDD VSS \$12405 HA_X1
X$16392 \$12351 VSS VDD \$12213 INV_X1
X$16393 VSS \$12146 \$12351 \$12352 \$11970 \$12046 VDD FA_X1
X$16394 \$12352 VSS VDD \$12245 INV_X1
X$16397 VSS \$12223 \$12246 \$12247 \$12148 \$12355 VDD FA_X1
X$16399 \$12248 VSS VDD \$12355 INV_X1
X$16401 VSS \$12218 \$12248 \$12224 \$12217 \$11886 VDD FA_X1
X$16406 \$12365 \$11404 \$12502 VDD VSS \$12223 HA_X1
X$16407 \$12118 VSS VDD \$12541 INV_X1
X$16408 \$12411 VSS VDD \$11888 CLKBUF_X1
X$16409 \$12224 VSS VDD \$12365 INV_X1
X$16412 \$12249 VSS VDD \$11551 CLKBUF_X1
X$16415 \$10147 \$10571 VSS VDD \$12250 NAND2_X1
X$16416 \$10147 \$10835 \$12252 VDD \$12412 VSS OAI21_X1
X$16417 \$10147 \$9773 VSS VDD \$12252 NAND2_X1
X$16420 \$8633 \$9773 VSS VDD \$12254 NAND2_X1
X$16423 \$8633 \$10571 VSS VDD \$12152 NAND2_X1
X$16424 \$12152 VSS VDD \$12513 INV_X1
X$16426 \$9773 \$8317 VSS VDD \$12371 NAND2_X1
X$16431 \$12128 VSS VDD \$12153 INV_X1
X$16434 \$12050 VSS VDD \$12132 INV_X1
X$16435 \$8317 \$10578 VSS VDD \$12050 NAND2_X1
X$16436 VSS \$12053 \$12155 \$12212 \$12215 \$12132 VDD FA_X1
X$16437 \$12639 VSS VDD \$10189 CLKBUF_X1
X$16439 \$8636 \$11584 VSS VDD \$12012 NAND2_X1
X$16440 \$12056 \$11900 \$12210 VDD VSS \$12157 HA_X1
X$16442 \$8144 \$11074 VSS VDD \$12159 NAND2_X1
X$16443 \$12159 VSS VDD \$12206 INV_X1
X$16444 VSS \$12057 \$12160 \$12265 \$12206 \$12125 VDD FA_X1
X$16445 \$12161 VSS VDD \$12125 INV_X1
X$16446 \$9133 \$10578 VSS VDD \$12161 NAND2_X1
X$16451 \$12371 VSS VDD \$12417 INV_X1
X$16455 \$10147 \$11584 VSS VDD \$12257 NAND2_X1
X$16458 \$10147 \$10578 VSS VDD \$12420 NAND2_X1
X$16459 VSS \$12154 \$13247 \$12258 \$12153 \$12380 VDD FA_X1
X$16460 \$8633 \$11584 VSS VDD \$12259 NAND2_X1
X$16461 \$12260 VSS VDD \$10392 CLKBUF_X1
X$16466 \$12155 VSS VDD \$12636 INV_X1
X$16468 \$9133 \$11074 VSS VDD \$12156 NAND2_X1
X$16469 \$12156 VSS VDD \$12215 INV_X1
X$16471 VSS \$12157 \$12504 \$12264 \$11447 \$12212 VDD FA_X1
X$16476 \$10571 \$9308 VSS VDD \$12549 NAND2_X1
X$16480 \$9133 \$10490 VSS VDD \$12791 NAND2_X1
X$16483 \$11584 \$9308 VSS VDD \$12199 NAND2_X1
X$16484 \$11084 VSS VDD \$I101749 INV_X4
X$16485 \$10578 \$8144 VSS VDD \$12164 NAND2_X1
X$16487 \$12164 VSS VDD \$12496 INV_X1
X$16490 \$9245 VSS VDD \$11084 CLKBUF_X3
X$16491 \$10836 \$9133 VSS VDD \$12272 NAND2_X1
X$16492 \$12199 VSS VDD \$12428 INV_X1
X$16493 \$12272 VSS VDD \$12273 INV_X1
X$16494 \$12058 VSS VDD \$12274 INV_X1
X$16496 \$12059 \$9308 \$10836 VDD VSS \$12116 AND3_X1
X$16498 \$12116 \$12061 \$12343 VDD VSS \$12166 HA_X1
X$16502 VSS \$12196 \$12850 \$12167 \$11909 \$12112 VDD FA_X1
X$16506 \$12110 VSS VDD \$12194 INV_X1
X$16508 \$8782 \$10578 \$12343 VDD VSS \$12275 AND3_X1
X$16514 VSS \$10411 \$12276 \$12432 \$10250 \$11987 VDD FA_X1
X$16516 VSS \$10411 \$12278 \$12329 \$10250 \$12064 VDD FA_X1
X$16518 VSS \$11786 \$12907 \$12434 \$12194 \$12168 VDD FA_X1
X$16519 VSS \$10411 \$12318 \$12100 \$10250 \$11916 VDD FA_X1
X$16520 \$12100 VSS VDD \$12066 INV_X1
X$16523 \$12329 VSS VDD \$12168 INV_X1
X$16526 \$12318 VSS VDD \$12443 INV_X1
X$16545 \$18639 VSS VDD \$18390 CLKBUF_X1
X$16547 \$18468 VSS VDD \$18391 CLKBUF_X1
X$16560 \$18719 VSS VDD \$18468 CLKBUF_X1
X$16562 \$18516 VSS VDD \$18598 CLKBUF_X1
X$16563 VSS \$17247 \$I99984 \$18605 \$18642 \$15672 VDD DFFR_X1
X$16564 \$18392 VSS VDD \$18519 CLKBUF_X1
X$16565 \$18519 VSS VDD \$18469 CLKBUF_X1
X$16566 \$18646 VSS VDD \$18516 CLKBUF_X1
X$16571 \$17817 \$15168 VSS VDD \$18526 NAND2_X1
X$16573 \$14199 \$17820 VSS VDD \$18523 OR2_X1
X$16576 \$17939 \$14199 VSS VDD \$18475 NAND2_X1
X$16577 \$18475 VSS VDD \$18398 INV_X1
X$16580 \$18452 VSS VDD \$18533 CLKBUF_X1
X$16581 \$18531 VSS VDD \$18541 INV_X1
X$16585 \$18470 VSS VDD \$17706 CLKBUF_X1
X$16587 \$18393 VSS VDD \$18599 INV_X1
X$16588 VSS \$18526 \$18471 \$18472 \$18523 \$18525 VDD FA_X1
X$16589 \$17939 \$14852 VSS VDD \$18525 NAND2_X1
X$16593 \$18532 VSS VDD \$18601 INV_X1
X$16596 \$15388 \$14852 VSS VDD \$18476 NAND2_X1
X$16597 \$17350 \$14852 VSS VDD \$18532 NAND2_X1
X$16600 \$18401 VSS VDD \$18603 INV_X1
X$16603 \$17350 \$14199 VSS VDD \$18604 NAND2_X1
X$16605 \$15168 \$16323 VDD VSS \$18606 AND2_X1
X$16608 \$15168 \$15388 VDD VSS \$18660 AND2_X1
X$16609 \$18403 VSS VDD \$18607 INV_X1
X$16610 \$16323 \$14199 VSS VDD \$18608 NAND2_X1
X$16612 \$18346 VSS VDD \$18479 CLKBUF_X1
X$16619 \$17900 VSS VDD \$18611 INV_X1
X$16623 \$18404 VSS VDD \$18851 INV_X1
X$16625 \$18082 VSS VDD \$18609 INV_X1
X$16629 \$18480 VSS VDD \$18610 INV_X1
X$16632 \$18481 VSS VDD \$18747 INV_X1
X$16634 \$17884 VSS VDD \$18558 CLKBUF_X1
X$16635 \$18612 VSS VDD \$18462 INV_X1
X$16636 \$18460 \$18462 \$18405 VDD VSS \$18483 HA_X1
X$16637 \$18162 \$18405 VDD VSS \$18466 XNOR2_X1
X$16643 \$18483 VSS VDD \$18406 INV_X1
X$16645 \$18556 VSS VDD \$18286 INV_X1
X$16647 \$18083 VSS VDD \$18461 CLKBUF_X1
X$16652 VSS \$16886 \$I100325 \$18484 \$18409 \$15541 VDD DFFR_X1
X$16653 \$18408 VSS VDD \$18409 CLKBUF_X1
X$16654 VSS \$18485 \$I100234 \$18488 \$18410 \$15541 VDD DFFR_X1
X$16655 \$18411 \$18457 \$18088 VDD VSS \$18571 HA_X1
X$16656 \$18571 VSS VDD \$18568 INV_X1
X$16657 \$18490 \$18491 VDD VSS \$18413 XNOR2_X1
X$16658 \$18413 VSS VDD \$18412 CLKBUF_X1
X$16659 \$18574 VSS VDD \$18415 CLKBUF_X1
X$16663 VSS \$16886 \$I100013 \$18614 \$18558 \$15541 VDD DFFR_X1
X$16665 \$18563 VSS VDD \$18486 CLKBUF_X1
X$16666 \$18487 VSS VDD \$18410 CLKBUF_X1
X$16667 \$18486 VSS VDD \$18487 CLKBUF_X1
X$16668 \$18673 VSS VDD \$18563 CLKBUF_X1
X$16671 \$18488 VSS VDD \$18411 CLKBUF_X1
X$16673 \$18489 \$18568 \$18565 VSS \$18670 VDD AOI21_X1
X$16676 \$18489 VSS VDD \$18491 CLKBUF_X1
X$16686 \$18391 VSS VDD \$17925 CLKBUF_X1
X$16698 VSS \$17598 \$I100031 \$18392 \$17375 \$15672 VDD DFFR_X1
X$16699 \$18227 VSS VDD \$18183 CLKBUF_X1
X$16703 \$18231 VSS VDD \$18184 CLKBUF_X1
X$16704 \$18230 VSS VDD \$18185 CLKBUF_X1
X$16705 \$17929 VSS VDD \$18230 CLKBUF_X1
X$16706 \$18185 VSS VDD \$18228 CLKBUF_X1
X$16707 \$18118 VSS VDD \$18231 CLKBUF_X1
X$16709 \$18068 VSS VDD \$18236 CLKBUF_X1
X$16710 \$18236 VSS VDD \$18239 CLKBUF_X1
X$16711 \$18237 VSS VDD \$18187 CLKBUF_X1
X$16712 \$18186 VSS VDD \$18069 CLKBUF_X1
X$16713 \$18187 VSS VDD \$18186 CLKBUF_X1
X$16714 \$18239 VSS VDD \$18237 CLKBUF_X1
X$16720 VSS \$18188 \$18393 \$18273 \$18318 \$18271 VDD FA_X1
X$16721 \$15168 \$17939 VDD VSS \$18271 AND2_X1
X$16724 \$18189 VSS VDD \$18188 INV_X1
X$16725 \$17817 \$14199 VSS VDD \$18189 NAND2_X1
X$16726 \$17820 \$13414 VSS VDD \$18318 NOR2_X1
X$16727 \$17247 VSS VDD \$I101715 INV_X2
X$16728 \$18328 VSS VDD \$18333 INV_X1
X$16731 \$17817 \$13414 VSS VDD \$18328 NAND2_X1
X$16732 \$17110 VSS VDD \$17247 CLKBUF_X3
X$16733 VSS \$18333 \$18600 \$18531 \$18192 \$18398 VDD FA_X1
X$16735 \$17939 VSS VDD \$18452 CLKBUF_X1
X$16737 \$17820 \$13098 VSS VDD \$18192 NOR2_X1
X$16742 \$18134 VSS VDD \$18346 CLKBUF_X1
X$16744 \$17817 \$13098 VSS VDD \$18194 NAND2_X1
X$16745 \$18194 VSS VDD \$18196 INV_X1
X$16746 \$17939 \$13098 VSS VDD \$18197 NAND2_X1
X$16750 \$17939 \$13414 VSS VDD \$18279 NAND2_X1
X$16751 \$18279 VSS VDD \$18342 INV_X1
X$16753 VSS \$18196 \$18401 \$18402 \$18251 \$18342 VDD FA_X1
X$16755 \$18197 VSS VDD \$18263 INV_X1
X$16758 VSS \$18261 \$18198 \$18265 \$18145 \$18263 VDD FA_X1
X$16759 \$16323 \$13414 VSS VDD \$18200 NAND2_X1
X$16760 \$18148 VSS VDD \$18202 CLKBUF_X1
X$16761 \$18200 VSS VDD \$18354 INV_X1
X$16763 \$18202 VSS VDD \$17884 CLKBUF_X1
X$16764 \$17350 \$13098 VSS VDD \$18204 NAND2_X1
X$16766 \$18204 VSS VDD \$18357 INV_X1
X$16769 \$18165 \$18286 \$18084 VSS VDD \$18366 NAND3_X1
X$16774 \$18198 VSS VDD \$18281 INV_X1
X$16776 \$17350 \$13414 VSS VDD \$18403 NAND2_X1
X$16779 \$15388 \$14199 VSS VDD \$18349 NAND2_X1
X$16782 \$18349 VSS VDD \$18356 INV_X1
X$16784 \$18265 VSS VDD \$18283 INV_X1
X$16785 VSS \$18354 \$18404 \$18158 \$18357 \$18356 VDD FA_X1
X$16790 \$17823 VSS VDD \$18460 INV_X1
X$16791 \$18405 VSS VDD \$18362 INV_X1
X$16795 \$18362 \$18162 \$18406 VDD \$18482 VSS OAI21_X1
X$16797 \$17386 \$18466 \$18083 VDD VSS \$18556 HA_X1
X$16798 \$18083 \$17943 VSS VDD \$18407 NAND2_X1
X$16801 \$17943 VSS VDD \$18369 INV_X1
X$16802 \$18369 \$18461 VDD VSS \$18408 XNOR2_X1
X$16806 \$18088 VSS VDD \$18087 CLKBUF_X1
X$16807 \$18088 \$17829 VSS VDD \$18565 NAND2_X1
X$16809 \$18089 \$18088 VSS VDD \$18372 NAND2_X1
X$16811 VSS \$16890 \$I100444 \$17553 \$18206 \$16907 VDD DFFR_X1
X$16814 \$18288 VSS VDD \$18266 INV_X1
X$16817 \$18208 VSS VDD \$17896 CLKBUF_X1
X$16819 \$18372 \$18568 \$18090 VSS VDD \$18490 NAND3_X1
X$16822 VSS \$16890 \$I99869 \$18416 \$18412 \$16907 VDD DFFR_X1
X$16824 \$18378 VSS VDD \$18206 CLKBUF_X1
X$16825 \$18417 VSS VDD \$18380 CLKBUF_X1
X$16826 \$18380 VSS VDD \$18378 CLKBUF_X1
X$16830 \$18383 VSS VDD \$18421 INV_X1
X$16833 VSS \$18596 \$18383 \$18423 \$18371 \$18385 VDD FA_X1
X$16836 \$18211 VSS VDD \$18210 INV_X1
X$16837 \$18210 \$18256 \$17837 VDD VSS \$18386 HA_X1
X$16839 \$18425 \$18381 \$17952 VDD VSS \$18385 HA_X1
X$16840 \$18374 VSS VDD \$18381 INV_X1
X$16841 \$16335 \$18093 VSS VDD \$18374 NAND2_X1
X$16842 \$18260 \$16486 VSS VDD \$18211 NAND2_X1
X$16845 \$17010 \$17398 VSS VDD \$18212 NAND2_X1
X$16846 \$18212 VSS VDD \$18365 INV_X1
X$16850 \$18097 VSS VDD \$18244 CLKBUF_X1
X$16851 \$17562 \$18244 VDD VSS \$18299 XNOR2_X1
X$16855 VSS \$18365 \$18371 \$18256 \$18358 \$18293 VDD FA_X1
X$16856 \$18052 \$16677 VSS VDD \$18297 NAND2_X1
X$16857 \$18297 VSS VDD \$18358 INV_X1
X$16860 \$18243 VSS VDD \$18332 INV_X1
X$16861 VSS \$16572 \$I100317 \$18243 \$18213 \$16907 VDD DFFR_X1
X$16864 \$18299 VSS VDD \$18213 CLKBUF_X1
X$16867 \$18139 \$18300 VSS VDD \$17559 NOR2_X2
X$16868 \$18301 \$18300 VSS VDD \$17398 NOR2_X2
X$16869 \$18332 \$18436 \$18301 \$18139 VSS VDD \$18314 NAND4_X1
X$16870 \$18332 \$18300 VSS VDD \$18093 NOR2_X2
X$16873 VSS \$17275 \$I100300 \$18216 \$17956 \$16907 VDD DFFR_X1
X$16882 \$17411 \$18216 VDD VSS \$16677 AND2_X1
X$16886 \$18104 \$18300 VSS VDD \$17843 NOR2_X1
X$16887 \$18106 VSS VDD \$18223 INV_X1
X$16888 \$18223 VSS VDD \$18225 CLKBUF_X1
X$16889 \$17411 \$18217 VDD VSS \$18110 AND2_X1
X$16890 VSS \$13995 \$I100348 \$18217 \$18221 \$16907 VDD DFFR_X1
X$16903 \$18303 VSS VDD \$18304 INV_X1
X$16904 \$18304 \$18300 VSS VDD \$17409 NOR2_X1
X$16910 \$18216 \$18217 \$18314 VSS VDD \$18305 NOR3_X1
X$16911 \$17453 \$18506 \$18305 VSS VDD \$18438 NAND3_X1
X$16915 \$17694 VSS VDD \$18307 CLKBUF_X1
X$16917 \$18306 VSS VDD \$18221 CLKBUF_X1
X$16918 \$18218 VSS VDD \$18306 CLKBUF_X1
X$16949 VSS \$19730 \$I100224 \$12618 \$19755 \$15672 VDD DFFR_X1
X$16956 \$19822 VSS VDD \$19755 CLKBUF_X1
X$16957 \$19936 VSS VDD \$19822 CLKBUF_X1
X$16958 \$19938 VSS VDD \$19823 CLKBUF_X1
X$16960 \$17110 VSS VDD \$19730 CLKBUF_X3
X$16961 VSS \$19730 \$I100133 \$19796 \$19731 \$15672 VDD DFFR_X1
X$16962 \$19644 VSS VDD \$19647 CLKBUF_X1
X$16964 \$19646 VSS VDD \$19645 CLKBUF_X1
X$16967 VSS \$19730 \$I100113 \$19948 \$19797 \$15541 VDD DFFR_X1
X$16969 \$15672 VSS VDD \$15541 BUF_X2
X$16970 \$19950 VSS VDD \$19835 CLKBUF_X1
X$16974 \$19696 VSS VDD \$19648 CLKBUF_X1
X$16976 \$19766 VSS VDD \$19706 CLKBUF_X1
X$16977 \$17365 VSS VDD \$19295 CLKBUF_X3
X$16978 VSS \$19295 \$I100270 \$19774 \$19706 \$15541 VDD DFFR_X1
X$16981 \$19774 VSS VDD \$19773 CLKBUF_X1
X$16983 \$19773 VSS VDD \$19734 CLKBUF_X1
X$16986 \$19844 VSS VDD \$19807 CLKBUF_X1
X$16988 \$19649 VSS VDD \$19597 CLKBUF_X1
X$16989 \$19650 VSS VDD \$19736 CLKBUF_X1
X$16990 \$19651 VSS VDD \$I101711 INV_X2
X$16991 VSS \$19651 \$I100158 \$17010 \$19652 \$15541 VDD DFFR_X1
X$16993 \$19653 VSS VDD \$19721 CLKBUF_X1
X$16997 VSS \$17247 \$I100072 \$16323 \$19798 \$15541 VDD DFFR_X1
X$17002 \$19801 VSS VDD \$19900 CLKBUF_X1
X$17005 VSS \$19295 \$I100124 \$19873 \$19802 \$15541 VDD DFFR_X1
X$17006 VSS \$19295 \$I99969 \$19804 \$19703 \$15541 VDD DFFR_X1
X$17007 VSS \$19295 \$I100116 \$19911 \$19805 \$15541 VDD DFFR_X1
X$17009 VSS \$19295 \$I100082 \$19847 \$19735 \$15541 VDD DFFR_X1
X$17010 \$17365 VSS VDD \$19651 CLKBUF_X3
X$17011 VSS \$19651 \$I100063 \$19855 \$19967 \$15541 VDD DFFR_X1
X$17012 \$19855 VSS VDD \$19859 CLKBUF_X1
X$17013 \$19786 \$19857 VDD VSS \$19739 XNOR2_X1
X$17014 \$19654 \$19598 \$19790 VDD \$19786 VSS OAI21_X1
X$17016 \$19738 VSS VDD \$19654 INV_X1
X$17020 \$19859 \$19861 \$19876 VDD VSS \$19862 HA_X1
X$17022 \$19739 VSS VDD \$19791 CLKBUF_X1
X$17023 \$19856 VSS VDD \$19861 INV_X1
X$17024 \$19862 VSS VDD \$19790 INV_X1
X$17026 \$19791 VSS VDD \$19864 INV_X1
X$17027 \$19864 \$19851 VSS VDD \$19897 NAND2_X1
X$17028 \$19739 \$19740 \$19742 VSS VDD \$19895 NAND3_X1
X$17029 \$19740 \$19742 VSS VDD \$19851 NAND2_X1
X$17031 \$19784 \$19655 \$19601 VSS \$19741 VDD AOI21_X1
X$17032 \$19656 \$19722 \$19655 VDD VSS \$19784 HA_X1
X$17035 \$19719 \$19743 VSS VDD \$19740 NAND2_X1
X$17037 \$19743 \$19719 VSS VDD \$19742 OR2_X1
X$17039 \$19781 VSS VDD \$19722 INV_X1
X$17044 \$18801 VSS VDD \$19719 INV_X1
X$17048 \$18624 \$18260 VSS VDD \$19779 XOR2_X1
X$17051 \$19779 \$18915 VSS VDD \$19879 NAND2_X1
X$17052 \$19777 VSS VDD \$19658 INV_X1
X$17056 \$19834 VSS VDD \$19809 INV_X1
X$17058 VSS \$19361 \$19834 \$19777 \$19201 \$19778 VDD FA_X1
X$17061 VSS \$19746 \$19778 \$19660 \$19709 \$19747 VDD FA_X1
X$17063 \$19454 VSS VDD \$19747 INV_X1
X$17064 \$17010 \$18915 VSS VDD \$19686 NAND2_X1
X$17065 \$19686 VSS VDD \$19767 INV_X1
X$17066 \$19664 VSS VDD \$19748 INV_X1
X$17068 \$18052 \$18915 VSS VDD \$19664 NAND2_X1
X$17070 \$18260 \$18915 VSS VDD \$19758 NAND2_X1
X$17071 \$18624 \$18804 VSS VDD \$19749 NAND2_X1
X$17074 \$18804 \$18260 VDD VSS \$19752 AND2_X1
X$17076 \$19756 VSS VDD \$19751 INV_X1
X$17095 \$19661 VSS VDD \$19810 INV_X1
X$17096 VSS \$19767 \$19882 \$19811 \$19747 \$19748 VDD FA_X1
X$17099 VSS \$19749 \$19973 \$19818 \$19821 \$19758 VDD FA_X1
X$17101 VSS \$19751 \$19814 \$19816 \$19455 \$19752 VDD FA_X1
X$17139 VSS \$14564 \$14506 \$14427 \$14507 \$13812 VDD FA_X1
X$17140 \$11561 \$13630 VDD VSS \$14564 AND2_X1
X$17143 \$14387 VSS VDD \$14736 INV_X1
X$17146 VSS \$14748 \$14509 \$14679 \$14390 \$14511 VDD FA_X1
X$17148 VSS \$14234 \$14514 \$14454 \$14586 \$14515 VDD FA_X1
X$17152 \$14591 VSS VDD \$14680 CLKBUF_X1
X$17162 \$14724 VSS VDD \$14722 INV_X1
X$17164 \$13958 \$10452 VSS VDD \$14724 NAND2_X1
X$17167 VSS \$13712 \$14674 \$14847 \$14304 \$14733 VDD FA_X1
X$17168 \$13630 \$10452 VSS VDD \$14678 NAND2_X1
X$17169 \$14678 VSS VDD \$15054 INV_X1
X$17173 \$14745 VSS VDD \$14748 INV_X1
X$17174 \$14679 \$14310 \$14749 VDD VSS \$14925 HA_X1
X$17175 VSS \$14754 \$14755 \$14760 \$14514 \$14392 VDD FA_X1
X$17176 VSS \$14763 \$14849 \$14850 \$14749 \$14760 VDD FA_X1
X$17180 VSS \$12464 \$I99947 \$14690 \$14680 \$12319 VDD DFFR_X1
X$17182 VSS \$14238 \$14517 \$14683 \$11833 \$12319 VDD DFFR_X1
X$17184 \$13150 VSS VDD \$14238 CLKBUF_X3
X$17191 \$14238 VSS VDD \$I91662 CLKBUF_X1
X$17192 \$14517 VSS VDD \$14777 CLKBUF_X1
X$17193 \$14777 VSS VDD \$15080 CLKBUF_X1
X$17194 \$14684 \$14237 \$14855 VDD \$14854 VSS OAI21_X1
X$17195 \$14393 \$14946 \$14685 VDD VSS \$14857 HA_X1
X$17196 \$14687 \$14684 VDD VSS \$14787 XNOR2_X1
X$17197 \$14688 VSS VDD \$14858 CLKBUF_X1
X$17199 VSS \$14238 \$I100078 \$14691 \$14787 \$10386 VDD DFFR_X1
X$17202 \$14690 VSS VDD \$14798 INV_X1
X$17203 \$14691 \$14859 VSS VDD \$14692 NOR2_X2
X$17204 \$14691 \$14798 VSS VDD \$14806 NOR2_X1
X$17205 \$12319 VSS VDD \$10386 BUF_X2
X$17211 VSS \$14244 \$I100434 \$14520 \$14619 \$10386 VDD DFFR_X1
X$17215 \$14798 \$14860 \$14692 VSS VDD \$14808 NAND3_X1
X$17216 \$14808 \$14861 VDD VSS \$14862 XNOR2_X1
X$17217 \$14806 \$14805 \$14241 \$14247 VSS VDD \$15117 NAND4_X1
X$17221 \$14108 VSS VDD \$13818 INV_X4
X$17227 \$14061 VSS VDD \$14469 CLKBUF_X1
X$17232 \$14108 \$14245 VDD VSS \$14625 AND2_X1
X$17234 VSS \$13622 \$I100296 \$14631 \$14632 \$10386 VDD DFFR_X1
X$17235 \$14526 VSS VDD \$14527 CLKBUF_X1
X$17237 \$14528 VSS VDD \$14478 CLKBUF_X1
X$17242 \$14695 VSS VDD \$14632 CLKBUF_X1
X$17243 \$14631 VSS VDD \$14107 CLKBUF_X1
X$17247 \$14696 VSS VDD \$14249 CLKBUF_X1
X$17248 VSS \$13622 \$I100422 \$13830 \$14643 \$10386 VDD DFFR_X1
X$17250 \$14531 \$14648 VDD VSS \$14250 XNOR2_X1
X$17255 \$14828 VSS VDD \$13500 CLKBUF_X1
X$17259 \$14839 VSS VDD \$14643 CLKBUF_X1
X$17260 \$14865 VSS VDD \$14645 CLKBUF_X1
X$17261 \$14996 \$14959 VDD VSS \$14839 XNOR2_X1
X$17263 \$14867 VSS VDD \$14866 INV_X1
X$17264 \$14869 VSS VDD \$14648 CLKBUF_X1
X$17267 \$14532 \$14372 VDD VSS \$14664 XNOR2_X1
X$17269 \$14401 \$14657 \$14651 VDD \$14532 VSS OAI21_X1
X$17271 \$14492 VSS VDD \$14535 INV_X1
X$17272 \$14534 \$14492 \$14536 VSS \$14657 VDD AOI21_X1
X$17273 \$14534 VSS VDD \$14663 INV_X1
X$17274 \$14662 \$14401 VDD VSS \$14836 XNOR2_X1
X$17275 \$14535 \$14500 \$14663 VDD \$14662 VSS OAI21_X1
X$17276 \$14536 \$14535 VDD VSS \$14537 XNOR2_X1
X$17283 \$13515 VSS VDD \$13984 CLKBUF_X1
X$17287 \$14361 \$14258 VDD VSS \$14539 XNOR2_X1
X$17292 \$14951 VSS VDD \$13209 CLKBUF_X1
X$17297 \$14540 \$14538 VSS VDD \$14541 XOR2_X1
X$17300 \$14268 \$14410 VDD VSS \$15196 XNOR2_X1
X$17303 \$14622 VSS VDD \$14628 CLKBUF_X1
X$17309 \$15143 \$14814 VSS VDD \$6881 XNOR2_X2
X$17312 \$14825 VSS VDD \$13343 CLKBUF_X1
X$17315 \$14820 \$14697 VSS VDD \$14878 NAND2_X1
X$17316 \$14818 \$14880 \$13571 VDD VSS \$14697 OAI21_X4
X$17317 \$14616 \$9015 \$14594 VSS VDD \$14820 NAND3_X1
X$17319 \$14616 VSS VDD \$14818 INV_X1
X$17325 \$14812 VSS VDD \$14881 INV_X1
X$17329 \$14698 VSS VDD \$15331 INV_X1
X$17331 \$14614 VSS VDD \$14452 INV_X1
X$17333 VSS \$14323 \$14614 \$14610 \$14543 \$14609 VDD FA_X1
X$17334 \$14610 VSS VDD \$14611 INV_X1
X$17336 \$14606 VSS VDD \$14609 INV_X1
X$17342 \$13571 \$14700 VDD VSS \$15098 AND2_X1
X$17345 VSS \$15207 \$14606 \$14444 \$14792 \$14414 VDD FA_X1
X$17347 \$14792 VSS VDD \$14603 INV_X1
X$17348 \$14884 \$13989 VSS VDD \$14792 NAND2_X1
X$17351 \$13844 \$13398 VSS VDD \$14598 NOR2_X1
X$17354 \$14702 \$14134 \$14547 VDD \$14574 VSS OAI21_X1
X$17355 \$14546 \$13571 \$14551 VDD VSS \$14552 HA_X1
X$17356 \$14547 \$14706 \$14548 \$14437 \$14576 VDD VSS \$14550 OAI221_X1
X$17357 \$14552 \$14551 \$14574 VSS \$14566 VDD AOI21_X1
X$17358 \$14552 VSS VDD \$14548 INV_X1
X$17361 \$14701 VSS VDD \$14931 INV_X1
X$17364 \$14703 VSS VDD \$14702 INV_X1
X$17365 \$14546 \$13679 \$14703 VDD VSS \$14770 HA_X1
X$17366 \$14703 VSS VDD \$14417 CLKBUF_X1
X$17367 \$14549 VSS VDD \$14758 CLKBUF_X1
X$17368 \$14928 \$14706 VDD VSS \$14738 XNOR2_X1
X$17369 \$14551 \$14703 VSS VDD \$14437 NAND2_X1
X$17370 \$14551 VSS VDD \$14706 INV_X1
X$17374 VSS \$14280 \$I100037 \$14420 \$14738 \$9850 VDD DFFR_X1
X$17376 \$14420 \$14568 \$14594 VSS VDD NOR2_X4
X$17377 \$13037 VSS VDD \$14280 CLKBUF_X3
X$17379 \$14711 VSS VDD \$14892 CLKBUF_X1
X$17380 \$14546 \$13989 \$14711 VDD VSS \$14895 HA_X1
X$17382 \$14568 VSS VDD \$10421 INV_X1
X$17383 \$14553 \$14566 \$14554 VDD \$14726 VSS OAI21_X1
X$17384 \$14895 VSS VDD \$14554 INV_X1
X$17385 \$14012 \$14553 VDD VSS \$14424 XNOR2_X1
X$17388 \$14894 \$14711 \$14012 VSS VDD \$14897 NAND3_X1
X$17396 \$14899 \$14713 VSS VDD \$14568 NAND2_X2
X$17397 \$14904 \$14714 VSS \$14713 VDD NAND2_X4
X$17398 \$14283 \$14282 VSS \$14556 VDD OR2_X4
X$17399 \$14556 \$14713 VDD \$13989 VSS AND2_X4
X$17406 VSS \$14556 \$14288 \$14420 \$15024 VDD NOR3_X4
X$17423 \$18899 VSS VDD \$I101698 INV_X2
X$17424 \$19037 VSS VDD \$18935 CLKBUF_X1
X$17425 \$18935 VSS VDD \$19061 CLKBUF_X1
X$17426 VSS \$18899 \$I100492 \$13015 \$18939 \$15672 VDD DFFR_X1
X$17432 \$19038 VSS VDD \$18939 CLKBUF_X1
X$17435 \$19039 VSS VDD \$18942 CLKBUF_X1
X$17440 \$18900 VSS VDD \$19040 CLKBUF_X1
X$17442 \$18774 VSS VDD \$18901 CLKBUF_X1
X$17444 VSS \$18836 \$18902 \$18949 \$18777 \$18778 VDD FA_X1
X$17447 VSS \$18344 \$18837 \$18778 \$18002 \$18839 VDD FA_X1
X$17448 VSS \$18958 \$18839 \$18775 \$18779 \$18601 VDD FA_X1
X$17449 \$18959 VSS VDD \$18958 INV_X1
X$17452 \$16323 \$14852 VSS VDD \$18959 NAND2_X1
X$17455 \$18901 VSS VDD \$19149 CLKBUF_X1
X$17459 \$18775 \$18902 VDD VSS \$19228 XNOR2_X1
X$17460 \$18776 \$18778 VDD VSS \$19041 XNOR2_X1
X$17464 \$17817 \$17939 VSS VDD \$18948 XOR2_X1
X$17465 \$18948 \$14852 VSS VDD \$19415 NAND2_X1
X$17468 \$18950 VSS VDD \$19079 INV_X1
X$17469 \$18903 VSS VDD \$19043 INV_X1
X$17471 VSS \$18281 \$19188 \$18967 \$18782 \$18966 VDD FA_X1
X$17472 \$18964 VSS VDD \$18966 INV_X1
X$17476 \$18743 VSS VDD \$19089 CLKBUF_X1
X$17480 VSS \$18972 \$19045 \$18970 \$18967 \$19085 VDD FA_X1
X$17482 VSS \$18783 \$19046 \$18976 \$18970 \$18965 VDD FA_X1
X$17484 \$18976 VSS VDD \$19088 INV_X1
X$17487 \$18973 \$19088 \$18784 VDD VSS \$18978 HA_X1
X$17488 \$18784 \$18482 VSS VDD \$18904 NAND2_X1
X$17490 \$18482 \$18784 VDD VSS \$18785 XNOR2_X1
X$17492 \$18686 VSS VDD \$18870 CLKBUF_X1
X$17494 \$18978 VSS VDD \$18979 INV_X1
X$17495 \$18979 \$18904 VSS VDD \$19190 NAND2_X1
X$17497 \$18786 VSS VDD \$19047 INV_X1
X$17501 \$18788 VSS VDD \$18789 CLKBUF_X1
X$17503 VSS \$18905 \$I100346 \$18987 \$18789 \$15541 VDD DFFR_X1
X$17505 \$18987 VSS VDD \$18907 CLKBUF_X1
X$17506 VSS \$18905 \$I100165 \$18910 \$18790 \$16907 VDD DFFR_X1
X$17508 \$18692 VSS VDD \$18691 CLKBUF_X1
X$17509 \$18989 \$18894 \$18692 VDD VSS \$18693 HA_X1
X$17513 VSS \$18905 \$I99956 \$19092 \$18871 \$15541 VDD DFFR_X1
X$17515 \$18907 VSS VDD \$19113 CLKBUF_X1
X$17516 \$19095 VSS VDD \$18988 CLKBUF_X1
X$17518 \$18909 VSS VDD \$18790 CLKBUF_X1
X$17519 \$18988 VSS VDD \$18909 CLKBUF_X1
X$17522 \$15541 VSS VDD \$16907 BUF_X2
X$17526 \$18910 VSS VDD \$18989 CLKBUF_X1
X$17528 \$18793 VSS VDD \$19049 INV_X1
X$17530 \$18911 \$19050 VSS VDD \$18574 XOR2_X1
X$17532 \$17365 VSS VDD \$18485 CLKBUF_X3
X$17533 \$18485 VSS VDD \$I69369 INV_X1
X$17536 \$18795 VSS VDD \$18894 INV_X1
X$17537 \$18419 \$18796 VDD VSS \$18795 XNOR2_X1
X$17538 \$18796 \$18419 VSS VDD \$18999 NAND2_X1
X$17541 \$18798 VSS VDD \$18426 CLKBUF_X1
X$17546 \$18997 \$18999 VSS VDD \$19052 NAND2_X1
X$17547 \$19002 \$19053 \$18796 VDD VSS \$19004 HA_X1
X$17548 \$19004 VSS VDD \$18997 INV_X1
X$17552 \$19003 VSS VDD \$19002 INV_X1
X$17553 VSS \$19010 \$19280 \$18912 \$19008 \$19120 VDD FA_X1
X$17554 \$18804 \$16672 VDD VSS \$18495 AND2_X1
X$17555 VSS \$18700 \$19003 \$18618 \$18912 \$18879 VDD FA_X1
X$17556 \$18802 VSS VDD \$18803 INV_X1
X$17561 \$16335 \$18804 VSS VDD \$19087 NAND2_X1
X$17564 \$16672 \$18915 VSS VDD \$19121 NAND2_X1
X$17565 \$16335 \$18915 VSS VDD \$19159 NAND2_X1
X$17568 \$18873 VSS VDD \$19010 INV_X1
X$17574 \$19019 VSS VDD \$19254 INV_X1
X$17576 VSS \$19033 \$19019 \$18867 \$18746 \$18864 VDD FA_X1
X$17578 \$18805 VSS VDD \$19033 INV_X1
X$17580 \$18624 \$16677 VSS VDD \$18805 NAND2_X1
X$17585 \$18260 \$17398 VSS VDD \$18918 NAND2_X1
X$17586 \$18918 VSS VDD \$18864 INV_X1
X$17589 \$18701 \$16677 VSS VDD \$19057 NOR2_X1
X$17591 \$18807 \$18804 \$18727 VDD VSS \$18711 HA_X1
X$17592 \$18710 VSS VDD \$19029 CLKBUF_X1
X$17593 \$18711 \$18727 \$18710 VSS \$18925 VDD AOI21_X1
X$17598 \$19029 \$18712 VDD VSS \$18921 XNOR2_X1
X$17599 VSS \$18501 \$I100004 \$18506 \$18921 \$16907 VDD DFFR_X1
X$17600 \$18501 VSS VDD \$I91890 CLKBUF_X1
X$17601 \$15560 VSS VDD \$18501 CLKBUF_X3
X$17602 \$18926 \$19075 \$18102 VSS VDD \$18985 NAND3_X1
X$17603 \$18833 VSS VDD \$18843 CLKBUF_X1
X$17608 \$18807 \$18828 \$18926 VDD VSS \$18953 HA_X1
X$17609 \$18983 VSS VDD \$18927 CLKBUF_X1
X$17610 \$18811 VSS VDD \$18983 CLKBUF_X1
X$17612 \$18928 \$18947 VDD VSS \$18713 XNOR2_X1
X$17613 VSS \$18501 \$18717 \$18931 \$18961 \$16907 VDD DFFR_X1
X$17614 \$18815 VSS VDD \$18507 INV_X1
X$17616 \$18717 \$18933 \$18633 VDD VSS \$18818 HA_X1
X$17631 \$19067 \$18963 \$18985 VSS VDD \$18928 NAND3_X1
X$17632 \$18927 VSS VDD \$18812 CLKBUF_X1
X$17633 \$18813 VSS VDD \$18947 CLKBUF_X1
X$17634 \$18953 VSS VDD \$18963 INV_X1
X$17639 \$18930 \$18506 \$19065 \$18931 VSS VDD \$18933 NAND4_X1
X$17640 \$18930 \$18931 VSS VDD \$18437 NOR2_X2
X$17677 \$14380 \$14432 \$14005 VDD VSS \$13947 HA_X1
X$17678 \$14224 VSS VDD \$14380 INV_X1
X$17679 \$12827 \$11743 VSS VDD \$14224 NAND2_X1
X$17680 \$14082 VSS VDD \$13949 INV_X1
X$17682 \$13958 \$11743 VSS VDD \$14082 NAND2_X1
X$17687 \$13958 \$11303 VSS VDD \$14225 NAND2_X1
X$17688 \$14225 VSS VDD \$14507 INV_X1
X$17689 \$14427 VSS VDD \$14298 INV_X1
X$17691 VSS \$14296 \$14508 \$15375 \$14430 \$14298 VDD FA_X1
X$17692 \$14226 VSS VDD \$14432 INV_X1
X$17694 VSS \$14306 \$14300 \$14227 \$14308 \$14157 VDD FA_X1
X$17695 \$14300 VSS VDD \$14296 INV_X1
X$17697 \$14086 VSS VDD \$14228 INV_X1
X$17698 \$14088 VSS VDD \$14229 INV_X1
X$17703 \$13015 \$11743 VSS VDD \$14226 NAND2_X1
X$17706 \$14227 VSS VDD \$14304 INV_X1
X$17708 \$13958 \$9658 VSS VDD \$14387 NAND2_X1
X$17712 \$14229 \$14228 \$14310 VDD VSS \$14510 HA_X1
X$17714 \$14389 VSS VDD \$14390 INV_X1
X$17715 \$13630 \$9658 VSS VDD \$14745 NAND2_X1
X$17716 \$14230 VSS VDD \$14511 INV_X1
X$17718 \$12618 \$10452 VSS VDD \$14230 NAND2_X1
X$17720 \$14231 VSS VDD \$14316 INV_X1
X$17721 \$13015 \$11303 VSS VDD \$14231 NAND2_X1
X$17722 \$14316 \$14089 \$14319 VDD VSS \$14392 HA_X1
X$17723 VSS \$14319 \$14324 \$14176 \$14320 \$13575 VDD FA_X1
X$17726 \$12618 \$9658 VSS VDD \$14232 NAND2_X1
X$17727 \$14090 VSS VDD \$14586 INV_X1
X$17728 \$14232 VSS VDD \$14515 INV_X1
X$17730 \$13963 VSS VDD \$14234 INV_X1
X$17732 \$14030 VSS VDD \$14455 INV_X1
X$17736 \$14322 \$14176 \$13964 VDD VSS \$14970 HA_X1
X$17738 \$14455 \$14454 \$14322 VDD VSS \$14763 HA_X1
X$17742 \$14331 \$13635 VDD VSS \$14591 XNOR2_X1
X$17743 \$14236 VSS VDD \$13635 INV_X1
X$17745 \$14393 \$14199 \$13967 VDD VSS \$14332 HA_X1
X$17746 \$14332 VSS VDD \$14182 INV_X1
X$17747 \$14092 VSS VDD \$13968 INV_X1
X$17749 \$13969 VSS VDD \$14093 CLKBUF_X1
X$17750 VSS \$14238 \$I100331 \$14397 \$14093 \$12319 VDD DFFR_X1
X$17752 \$14393 \$15168 \$14236 VDD VSS \$14092 HA_X1
X$17753 \$14092 \$14236 \$14331 VSS \$14237 VDD AOI21_X1
X$17755 \$14397 VSS VDD \$14095 CLKBUF_X1
X$17757 \$14095 VSS VDD \$14192 INV_X1
X$17758 \$14192 \$13818 VSS VDD \$14199 NOR2_X2
X$17764 \$14209 \$14049 VSS VDD \$14241 NOR2_X1
X$17765 \$14096 VSS VDD \$14242 CLKBUF_X1
X$17766 \$14098 \$13818 VSS VDD \$13178 NOR2_X2
X$17769 VSS \$12532 \$I99960 \$14465 \$14242 \$10386 VDD DFFR_X1
X$17770 \$14100 \$13818 VSS VDD \$13181 NOR2_X2
X$17771 \$14098 \$14102 \$14347 \$14100 VSS VDD \$14209 NAND4_X1
X$17773 \$13650 VSS VDD \$14619 CLKBUF_X1
X$17775 \$14347 \$13818 VSS VDD \$13651 NOR2_X1
X$17776 \$14102 \$13818 VSS VDD \$13653 NOR2_X1
X$17779 \$14103 VSS VDD \$14102 INV_X1
X$17781 \$14465 VSS VDD \$14100 INV_X1
X$17785 \$14520 VSS VDD \$14347 INV_X1
X$17788 \$14104 VSS VDD \$14105 CLKBUF_X1
X$17790 VSS \$14244 \$I100432 \$14245 \$14105 \$10386 VDD DFFR_X1
X$17793 \$14107 \$14108 VSS VDD \$13662 NAND2_X1
X$17795 \$14359 VSS VDD \$13240 CLKBUF_X1
X$17796 \$14362 \$14219 \$14358 VDD VSS \$13936 HA_X1
X$17797 \$14110 VSS VDD \$14474 CLKBUF_X1
X$17799 \$14363 VSS VDD \$14362 CLKBUF_X1
X$17802 VSS \$14244 \$I99859 \$14246 \$14469 \$10386 VDD DFFR_X1
X$17803 \$14108 \$14246 VDD VSS \$13660 AND2_X1
X$17804 \$14246 \$14245 \$14528 \$14631 VSS VDD \$14247 NOR4_X1
X$17805 \$14474 VSS VDD \$14695 INV_X1
X$17806 \$14358 VSS VDD \$14476 CLKBUF_X1
X$17807 \$14108 \$14478 VDD VSS \$14219 AND2_X1
X$17809 \$14476 VSS VDD \$14526 CLKBUF_X1
X$17810 VSS \$13622 \$I99909 \$14528 \$14527 \$10386 VDD DFFR_X1
X$17811 \$14215 VSS VDD \$14363 CLKBUF_X1
X$17812 \$12743 VSS VDD \$13622 CLKBUF_X3
X$17813 \$14080 VSS VDD \$14215 CLKBUF_X1
X$17814 \$14250 VSS VDD \$13617 CLKBUF_X1
X$17817 VSS \$14252 \$I100293 \$14213 \$14645 \$10386 VDD DFFR_X1
X$17821 \$14069 \$14113 \$14253 VDD VSS \$14254 HA_X1
X$17824 \$13832 VSS VDD \$14490 INV_X1
X$17827 \$14115 \$14114 \$14402 VDD VSS \$14116 HA_X1
X$17828 \$14116 VSS VDD \$14255 INV_X1
X$17831 \$14834 VSS VDD \$12260 CLKBUF_X1
X$17833 \$14206 \$14203 \$14404 VDD VSS \$14488 HA_X1
X$17838 \$14400 VSS VDD \$13469 CLKBUF_X1
X$17843 \$14253 VSS VDD \$14401 INV_X1
X$17846 \$14254 VSS VDD \$14651 INV_X1
X$17848 \$14490 \$14210 \$14492 VDD VSS \$14534 HA_X1
X$17852 \$14402 VSS VDD \$14499 INV_X1
X$17853 \$14499 \$14379 \$14255 VDD \$14536 VSS OAI21_X1
X$17854 \$14116 \$14402 \$14504 VSS \$14500 VDD AOI21_X1
X$17855 \$14256 VSS VDD \$14504 INV_X1
X$17856 \$14256 \$14402 VDD VSS \$14496 XNOR2_X1
X$17858 \$14488 \$14404 \$14405 VSS \$14379 VDD AOI21_X1
X$17859 \$14488 \$14404 \$14485 VSS \$14256 VDD AOI21_X1
X$17860 \$14405 \$14404 VSS VDD \$14257 XOR2_X1
X$17861 \$14197 \$14196 \$14258 VDD VSS \$14374 HA_X1
X$17863 \$14374 VSS VDD \$14259 INV_X1
X$17867 \$14258 VSS VDD \$14483 INV_X1
X$17868 \$14483 \$14361 \$14259 VDD \$14485 VSS OAI21_X1
X$17870 \$14117 \$14190 \$14538 VDD VSS \$14119 HA_X1
X$17872 \$14118 VSS VDD \$12814 CLKBUF_X1
X$17876 \$14119 \$14258 VSS VDD \$14260 NAND2_X1
X$17877 \$14260 \$14352 \$14259 \$14261 VSS VDD \$14405 NAND4_X1
X$17878 \$14119 \$14538 \$14466 VSS \$14361 VDD AOI21_X1
X$17879 \$14258 \$14538 VSS VDD \$14264 NAND2_X1
X$17880 \$14264 VSS VDD \$14265 INV_X1
X$17882 \$14265 \$14412 VSS VDD \$14352 NAND2_X1
X$17884 \$14265 \$14120 \$13900 \$14123 VSS VDD \$14261 NAND4_X1
X$17886 \$14052 \$14409 VSS VDD \$14466 NAND2_X1
X$17887 \$14120 \$14268 VSS VDD \$14409 NAND2_X1
X$17888 \$14120 VSS VDD \$14410 INV_X1
X$17889 \$14410 \$14266 \$14052 VDD \$14540 VSS OAI21_X1
X$17890 \$13836 \$13900 \$14123 VSS \$14266 VDD AOI21_X1
X$17892 \$13836 VSS VDD \$14267 INV_X1
X$17894 \$14267 \$14410 \$14052 VDD \$14412 VSS OAI21_X1
X$17895 \$14267 \$14457 VSS VDD \$14268 NAND2_X1
X$17897 \$13900 \$14045 VSS VDD \$14457 NAND2_X1
X$17900 \$14269 VSS VDD \$14123 INV_X1
X$17901 \$14269 \$13900 VDD VSS \$14270 XNOR2_X1
X$17904 \$13986 \$13776 VDD VSS \$14877 XNOR2_X1
X$17912 \$14336 VSS VDD \$14185 INV_X1
X$17913 \$13513 \$14177 VDD VSS \$14329 XNOR2_X1
X$17914 \$14329 \$14126 VDD VSS \$14812 XNOR2_X1
X$17916 \$14939 VSS VDD \$13194 CLKBUF_X1
X$17920 \$13674 \$14456 VDD VSS \$14271 XNOR2_X1
X$17921 \$14125 \$14271 VDD VSS \$14616 XNOR2_X1
X$17923 VSS \$14325 \$14456 \$14698 \$14326 \$14452 VDD FA_X1
X$17925 VSS \$14323 \$14177 \$14126 \$14543 \$14170 VDD FA_X1
X$17927 VSS \$14318 \$14170 \$13846 \$14603 \$14129 VDD FA_X1
X$17930 \$14032 VSS VDD \$14326 INV_X1
X$17932 VSS \$14321 \$14325 \$14272 \$14128 \$14611 VDD FA_X1
X$17936 \$14414 VSS VDD \$14318 INV_X1
X$17937 \$14700 \$13989 VSS VDD \$14414 NAND2_X1
X$17939 VSS \$14275 \$14321 \$15296 \$14274 \$14444 VDD FA_X1
X$17940 \$13849 VSS VDD \$14274 INV_X1
X$17945 \$14443 VSS VDD \$14275 INV_X1
X$17948 VSS \$14311 \$14443 \$14701 \$14598 \$14416 VDD FA_X1
X$17949 \$13515 \$13680 VSS VDD \$14277 NAND2_X1
X$17951 \$14277 VSS VDD \$14311 INV_X1
X$17955 \$14133 VSS VDD \$13851 CLKBUF_X1
X$17958 \$13854 VSS VDD \$14305 INV_X1
X$17959 \$14017 VSS VDD \$14278 CLKBUF_X1
X$17960 \$13350 \$14017 \$14305 VDD \$14136 VSS OAI21_X1
X$17963 \$14155 VSS VDD \$14137 CLKBUF_X1
X$17966 \$14441 VSS VDD \$14416 INV_X1
X$17968 \$13678 \$13872 VSS VDD \$14441 NAND2_X1
X$17972 \$13853 \$14417 VDD VSS \$14549 XNOR2_X1
X$17974 \$14136 VSS VDD \$14576 INV_X1
X$17975 VSS \$14280 \$I99998 \$14152 \$14758 \$9850 VDD DFFR_X1
X$17976 \$14418 VSS VDD \$13679 INV_X2
X$17977 \$14419 \$10421 VSS VDD \$14418 NAND2_X1
X$17978 \$10421 \$13856 VDD VSS \$13680 AND2_X1
X$17979 \$10421 \$14140 VDD VSS \$13872 AND2_X1
X$17984 VSS \$14282 \$14144 \$14288 \$14283 \$14291 VDD NOR4_X4
X$17991 \$14152 VSS VDD \$14419 CLKBUF_X1
X$17994 VSS \$14280 \$I99833 \$14283 \$14424 \$9850 VDD DFFR_X1
X$17997 \$14420 VSS VDD \$14144 INV_X2
X$17998 \$14283 \$14420 \$14288 \$14282 VSS VDD \$14285 NAND4_X1
X$18025 \$141 VSS VDD \$164 INV_X1
X$18026 \$143 \$109 \$141 VDD VSS \$183 HA_X1
X$18028 \$145 VSS VDD \$143 INV_X1
X$18029 VSS \$150 \$145 \$166 \$113 \$151 VDD FA_X1
X$18031 \$82 VSS VDD \$151 INV_X1
X$18043 \$164 \$165 \$182 VDD \$217 VSS OAI21_X1
X$18045 \$183 VSS VDD \$182 INV_X1
X$18049 \$217 \$146 VSS VDD \$199 XOR2_X1
X$18053 \$166 VSS VDD \$219 INV_X1
X$18055 VSS \$155 \$150 \$185 \$154 \$67 VDD FA_X1
X$18058 VSS \$129 \$112 \$154 \$97 \$163 VDD FA_X1
X$18063 VSS \$221 \$155 \$500 \$162 \$97 VDD FA_X1
X$18066 \$293 \$33 VSS VDD \$127 NAND2_X1
X$18068 \$919 VSS VDD \$72 INV_X1
X$18069 \$169 \$33 VSS VDD \$73 NAND2_X1
X$18070 \$137 \$43 VSS VDD \$98 NAND2_X1
X$18071 VSS \$160 \$163 \$162 \$193 \$133 VDD FA_X1
X$18072 \$137 \$153 VSS VDD \$133 NAND2_X1
X$18077 \$137 VSS VDD \$169 INV_X1
X$18080 \$201 \$153 VSS VDD \$202 NAND2_X1
X$18081 \$197 \$33 VSS VDD \$193 NAND2_X1
X$18084 \$201 \$43 VSS VDD \$160 NAND2_X1
X$18086 \$76 VSS VDD \$101 CLKBUF_X1
X$18100 \$77 VSS VDD \$I68456 INV_X1
X$18101 \$191 VSS VDD \$77 CLKBUF_X3
X$18104 \$207 VSS VDD \$208 CLKBUF_X1
X$18106 \$78 VSS VDD \$103 CLKBUF_X1
X$18108 \$140 VSS VDD \$104 CLKBUF_X1
X$18136 \$174 \$173 VSS VDD \$175 NAND2_X1
X$18137 \$175 \$188 \$209 VSS VDD \$223 NAND3_X1
X$18138 \$173 \$176 \$215 VSS VDD \$209 NAND3_X1
X$18140 \$173 VSS VDD \$177 INV_X1
X$18142 \$211 \$177 VDD VSS \$178 XNOR2_X1
X$18145 \$178 VSS VDD \$179 CLKBUF_X1
X$18146 VSS \$274 \$I100136 \$313 \$179 \$85 VDD DFFR_X1
X$18292 \$26 \$48 VDD VSS \$66 XNOR2_X1
X$18294 \$37 \$82 VDD VSS \$26 XNOR2_X1
X$18296 VSS \$18 \$37 \$56 \$67 \$54 VDD FA_X1
X$18297 \$30 VSS VDD \$18 INV_X1
X$18299 \$40 VSS VDD \$54 INV_X1
X$18300 VSS \$39 \$40 \$32 \$92 \$31 VDD FA_X1
X$18304 \$63 VSS VDD \$39 INV_X1
X$18312 \$19 VSS VDD \$25 INV_X1
X$18319 \$38 \$20 VSS VDD \$19 NOR2_X1
X$18322 \$85 \$21 VSS VDD \$20 NAND2_X1
X$18346 VSS \$77 \$I100023 \$47 \$52 \$85 VDD DFFR_X1
X$18396 \$97 \$49 VDD VSS \$48 XNOR2_X1
X$18397 VSS \$90 \$49 \$109 \$82 \$41 VDD FA_X1
X$18398 \$87 VSS VDD \$41 INV_X1
X$18399 \$56 VSS VDD \$90 INV_X1
X$18401 \$42 VSS VDD \$67 INV_X1
X$18402 \$42 \$55 VDD VSS \$91 XNOR2_X1
X$18403 VSS \$69 \$55 \$30 \$92 \$65 VDD FA_X1
X$18404 \$97 VSS VDD \$92 INV_X1
X$18405 \$32 VSS VDD \$121 INV_X1
X$18406 \$70 VSS VDD \$31 INV_X1
X$18409 \$71 VSS VDD \$65 INV_X1
X$18410 VSS \$73 \$71 \$63 \$72 \$61 VDD FA_X1
X$18412 VSS \$75 \$I100254 \$74 \$43 \$45 VDD DFFR_X1
X$18413 VSS \$75 \$I100381 \$203 \$44 \$45 VDD DFFR_X1
X$18418 \$19 VSS VDD \$52 CLKBUF_X1
X$18432 \$66 \$115 VDD VSS \$146 XNOR2_X1
X$18436 VSS \$121 \$87 \$113 \$67 \$112 VDD FA_X1
X$18439 \$91 \$69 VDD VSS \$115 XNOR2_X1
X$18443 VSS \$98 \$70 \$129 \$127 \$72 VDD FA_X1
X$18445 \$131 VSS VDD \$61 INV_X1
X$18447 \$134 VSS VDD \$100 CLKBUF_X1
X$18448 \$74 VSS VDD \$134 CLKBUF_X1
X$18449 \$100 VSS VDD \$76 CLKBUF_X1
X$18450 \$101 VSS VDD \$132 CLKBUF_X1
X$18451 \$132 VSS VDD \$44 CLKBUF_X1
X$18455 \$45 VSS VDD \$85 BUF_X1
X$18458 VSS \$77 \$I100028 \$105 \$103 \$85 VDD DFFR_X1
X$18459 \$104 VSS VDD \$83 CLKBUF_X1
X$18461 \$83 VSS VDD \$78 CLKBUF_X1
X$18462 \$81 VSS VDD \$140 CLKBUF_X1
X$18463 \$47 VSS VDD \$81 CLKBUF_X1
X$18531 \$198 VSS VDD \$231 INV_X1
X$18532 \$247 \$198 \$232 VSS \$165 VDD AOI21_X1
X$18533 \$248 \$219 \$198 VDD VSS \$247 HA_X1
X$18543 \$281 \$164 VDD VSS \$279 XNOR2_X1
X$18544 \$231 \$481 \$297 VDD \$281 VSS OAI21_X1
X$18545 \$247 VSS VDD \$297 INV_X1
X$18548 \$251 VSS VDD \$248 INV_X1
X$18554 \$201 VSS VDD \$293 INV_X1
X$18555 VSS \$270 \$221 \$234 \$233 \$202 VDD FA_X1
X$18559 VSS \$328 \$251 \$299 \$185 \$298 VDD FA_X1
X$18561 VSS \$437 \$82 \$42 \$436 \$300 VDD FA_X1
X$18564 \$333 VSS VDD \$300 INV_X1
X$18567 VSS \$265 \$333 \$97 \$504 \$420 VDD FA_X1
X$18568 \$266 VSS VDD \$265 INV_X1
X$18571 \$267 VSS VDD \$422 INV_X1
X$18576 \$301 \$33 VSS VDD \$233 NAND2_X1
X$18578 \$385 \$43 VSS VDD \$270 NAND2_X1
X$18581 \$75 VSS VDD \$I101756 INV_X4
X$18582 \$191 VSS VDD \$75 CLKBUF_X3
X$18583 VSS \$75 \$I100535 \$236 \$263 \$45 VDD DFFR_X1
X$18584 VSS \$77 \$I100362 \$389 \$272 \$45 VDD DFFR_X1
X$18585 \$428 VSS VDD \$205 INV_X1
X$18586 VSS \$77 \$I100215 \$238 \$205 \$45 VDD DFFR_X1
X$18587 VSS \$77 \$I100361 \$240 \$239 \$85 VDD DFFR_X1
X$18590 \$360 VSS VDD \$294 CLKBUF_X1
X$18591 \$236 VSS VDD \$360 CLKBUF_X1
X$18592 \$294 VSS VDD \$306 CLKBUF_X1
X$18593 \$365 VSS VDD \$366 CLKBUF_X1
X$18594 \$366 VSS VDD \$272 CLKBUF_X1
X$18598 \$371 VSS VDD \$292 CLKBUF_X1
X$18599 \$307 VSS VDD \$373 CLKBUF_X1
X$18600 \$238 VSS VDD \$307 CLKBUF_X1
X$18601 \$375 VSS VDD \$239 CLKBUF_X1
X$18602 \$373 VSS VDD \$371 CLKBUF_X1
X$18603 \$292 VSS VDD \$375 CLKBUF_X1
X$18604 \$290 VSS VDD \$308 CLKBUF_X1
X$18605 \$259 VSS VDD \$381 CLKBUF_X1
X$18606 \$308 VSS VDD \$207 CLKBUF_X1
X$18607 VSS \$77 \$I100149 \$722 \$381 \$85 VDD DFFR_X1
X$18608 \$240 VSS VDD \$290 CLKBUF_X1
X$18609 \$208 VSS VDD \$259 CLKBUF_X1
X$18614 \$273 VSS VDD \$289 CLKBUF_X1
X$18616 \$256 VSS VDD \$188 INV_X1
X$18617 \$393 \$284 \$173 VDD VSS \$256 HA_X1
X$18618 \$174 VSS VDD \$252 INV_X1
X$18619 \$176 VSS VDD \$210 INV_X1
X$18620 \$210 \$398 \$252 VDD \$211 VSS OAI21_X1
X$18621 \$215 \$210 VDD VSS \$241 XNOR2_X1
X$18622 VSS \$274 \$I100479 \$243 \$241 \$85 VDD DFFR_X1
X$18643 \$289 VSS VDD \$364 CLKBUF_X1
X$18644 \$357 \$364 VSS VDD \$310 XOR2_X1
X$18646 \$223 \$459 VDD VSS \$421 XNOR2_X1
X$18648 \$311 \$395 \$353 VSS \$284 VDD AOI21_X1
X$18649 \$280 \$311 VSS VDD \$357 NOR2_X1
X$18651 \$313 VSS VDD \$353 INV_X1
X$18652 VSS \$274 \$338 \$275 \$350 \$85 VDD DFFR_X1
X$18653 \$313 \$275 VSS VDD \$332 NOR2_X1
X$18654 \$462 \$313 VSS VDD \$403 NOR2_X1
X$18655 \$338 \$314 VSS VDD \$335 NAND2_X1
X$18656 \$243 \$315 VSS VDD \$331 NOR2_X1
X$18658 \$332 \$331 VSS VDD \$330 NAND2_X1
X$18663 VSS \$464 \$I100143 \$276 \$324 \$327 VDD DFFR_X1
X$18667 \$471 VSS VDD \$323 INV_X1
X$18668 \$278 \$323 \$493 VDD VSS \$411 HA_X1
X$18669 \$474 VSS VDD \$316 INV_X1
X$18671 \$317 VSS VDD \$278 CLKBUF_X1
X$18713 dxin[0] VSS VDD \$912 BUF_X1
X$18723 \$741 VSS VDD \$739 INV_X1
X$18724 \$739 \$859 VSS VDD \$232 NAND2_X1
X$18725 \$831 VSS VDD \$573 INV_X1
X$18726 \$712 \$713 VSS VDD \$741 NAND2_X1
X$18727 \$614 VSS VDD \$712 INV_X1
X$18731 VSS \$752 \$574 \$751 \$344 \$576 VDD FA_X1
X$18734 \$611 \$1063 \$964 VSS VDD \$859 NAND3_X1
X$18735 \$913 \$611 VSS VDD \$713 NAND2_X1
X$18738 \$972 VSS VDD \$967 INV_X1
X$18742 \$978 VSS VDD \$914 INV_X1
X$18743 VSS \$873 \$978 \$1109 \$436 \$437 VDD FA_X1
X$18745 VSS \$877 \$752 \$715 \$580 \$754 VDD FA_X1
X$18751 VSS \$75 \$578 \$1348 \$585 \$45 VDD DFFR_X1
X$18752 VSS \$589 \$833 \$201 \$891 \$45 VDD DFFR_X1
X$18754 \$788 VSS VDD \$784 CLKBUF_X1
X$18755 VSS \$589 \$786 \$137 \$801 \$45 VDD DFFR_X1
X$18757 \$805 VSS VDD \$906 CLKBUF_X1
X$18758 \$808 VSS VDD \$794 CLKBUF_X1
X$18762 \$984 VSS VDD \$873 INV_X1
X$18765 VSS \$882 \$877 \$1125 \$920 \$921 VDD FA_X1
X$18766 \$386 \$153 VSS VDD \$921 NAND2_X1
X$18767 \$922 \$43 VSS VDD \$882 NAND2_X1
X$18773 \$922 VSS VDD \$886 INV_X1
X$18775 \$578 VSS VDD \$1002 CLKBUF_X1
X$18777 \$833 VSS VDD \$1068 INV_X1
X$18780 \$201 VSS VDD \$1350 CLKBUF_X1
X$18781 \$1016 VSS VDD \$891 CLKBUF_X1
X$18782 \$589 VSS VDD \$I92441 CLKBUF_X1
X$18784 \$1011 VSS VDD \$1069 CLKBUF_X1
X$18786 \$906 VSS VDD \$1016 CLKBUF_X1
X$18788 \$1024 VSS VDD \$801 CLKBUF_X1
X$18790 \$930 VSS VDD \$1024 CLKBUF_X1
X$18792 \$910 VSS VDD \$930 CLKBUF_X1
X$18793 \$834 VSS VDD \$805 CLKBUF_X1
X$18795 \$810 VSS VDD \$834 CLKBUF_X1
X$18796 VSS \$720 \$I100464 \$817 \$813 \$85 VDD DFFR_X1
X$18797 \$449 VSS VDD \$810 CLKBUF_X1
X$18801 \$448 VSS VDD \$931 CLKBUF_X1
X$18802 \$1025 VSS VDD \$910 CLKBUF_X1
X$18804 \$1028 VSS VDD \$1025 CLKBUF_X1
X$18806 \$817 VSS VDD \$1028 CLKBUF_X1
X$18809 \$384 VSS VDD \$681 CLKBUF_X1
X$18810 \$836 VSS VDD \$591 INV_X1
X$18811 \$825 VSS VDD \$680 CLKBUF_X1
X$18812 \$901 \$835 VSS VDD \$688 NAND2_X1
X$18813 \$453 VSS VDD \$825 CLKBUF_X1
X$18814 \$836 \$901 \$835 VSS VDD \$452 NAND3_X1
X$18816 \$812 VSS VDD \$820 CLKBUF_X1
X$18817 VSS \$720 \$I100489 \$803 \$723 \$85 VDD DFFR_X1
X$18818 \$892 VSS VDD \$802 CLKBUF_X1
X$18821 \$191 VSS VDD \$720 CLKBUF_X3
X$18822 \$1032 VSS VDD \$813 CLKBUF_X1
X$18824 \$935 \$894 VSS VDD \$835 NAND2_X1
X$18825 \$837 VSS VDD \$935 INV_X1
X$18826 \$837 \$937 \$838 VSS VDD \$901 NAND3_X1
X$18827 \$895 VSS VDD \$1032 CLKBUF_X1
X$18828 \$937 \$838 VSS VDD \$894 NAND2_X1
X$18830 \$1049 VSS VDD \$895 CLKBUF_X1
X$18831 \$1051 VSS VDD \$724 CLKBUF_X1
X$18833 \$803 VSS VDD \$1051 CLKBUF_X1
X$18835 \$1055 VSS VDD \$1049 CLKBUF_X1
X$18837 \$798 VSS VDD \$892 CLKBUF_X1
X$18841 \$1058 VSS VDD \$1055 CLKBUF_X1
X$18843 VSS \$274 \$I100383 \$889 \$1047 \$85 VDD DFFR_X1
X$18847 \$727 \$726 VSS VDD \$839 XOR2_X1
X$18849 \$404 VSS VDD \$841 INV_X1
X$18854 \$889 VSS VDD \$1058 CLKBUF_X1
X$18859 \$594 \$397 VSS VDD \$940 NAND2_X1
X$18860 \$839 \$841 \$397 VSS VDD \$887 NAND3_X2
X$18864 \$1081 \$941 VDD VSS \$728 XNOR2_X1
X$18866 VSS \$274 \$I100505 \$462 \$728 \$85 VDD DFFR_X1
X$18870 \$777 \$781 VSS VDD \$600 NOR2_X1
X$18872 \$397 \$395 \$777 VDD VSS \$762 AND3_X1
X$18873 \$775 VSS VDD \$638 CLKBUF_X1
X$18875 \$769 VSS VDD \$775 CLKBUF_X1
X$18877 \$731 \$845 \$944 \$771 \$470 VDD VSS \$946 OAI221_X1
X$18878 \$847 \$602 VSS VDD \$771 NAND2_X1
X$18879 \$760 \$731 \$761 VSS VDD \$846 NAND3_X1
X$18880 \$755 \$762 \$876 VDD VSS \$758 HA_X1
X$18881 \$758 VSS VDD \$731 INV_X1
X$18882 VSS \$476 \$I100304 \$872 \$740 \$327 VDD DFFR_X1
X$18883 \$476 VSS VDD \$I101716 INV_X2
X$18884 \$750 VSS VDD \$476 CLKBUF_X3
X$18887 \$737 VSS VDD \$747 INV_X1
X$18889 \$864 \$734 VDD VSS \$740 XNOR2_X1
X$18890 \$734 VSS VDD \$850 INV_X1
X$18900 VSS \$464 \$I100147 \$781 \$1021 \$327 VDD DFFR_X1
X$18901 \$397 \$395 \$781 VDD VSS \$844 AND3_X1
X$18907 \$846 \$943 VDD VSS \$945 XNOR2_X1
X$18908 \$847 \$846 VSS VDD \$848 NAND2_X1
X$18910 \$876 VSS VDD \$602 CLKBUF_X1
X$18913 \$872 VSS VDD \$755 CLKBUF_X1
X$18916 \$866 \$985 \$851 VSS \$1179 VDD AOI21_X1
X$18917 \$860 \$850 \$947 VDD \$866 VSS OAI21_X1
X$18918 VSS \$852 \$864 \$737 \$986 \$948 VDD FA_X1
X$18920 \$735 VSS VDD \$985 INV_X1
X$18921 \$734 \$738 VSS VDD \$735 NAND2_X1
X$18923 \$857 VSS VDD \$860 INV_X1
X$18924 \$855 \$736 \$738 VDD VSS \$857 HA_X1
X$18937 \$851 VSS VDD \$948 INV_X1
X$18938 \$852 VSS VDD \$855 INV_X1
X$18941 \$952 \$969 \$607 VDD VSS \$851 HA_X1
X$18944 \$960 VSS VDD \$969 INV_X1
X$18947 VSS \$956 \$852 \$960 \$958 \$951 VDD FA_X1
X$18970 \$4244 VSS VDD \$4245 CLKBUF_X1
X$18971 \$4323 VSS VDD \$4244 CLKBUF_X1
X$18972 \$4327 VSS VDD \$4483 CLKBUF_X1
X$18973 VSS \$3244 \$I99803 \$4116 \$4033 \$3006 VDD DFFR_X1
X$18974 \$4484 VSS VDD \$4033 CLKBUF_X1
X$18976 \$3903 VSS VDD \$4331 CLKBUF_X1
X$18977 \$4330 VSS VDD \$3904 CLKBUF_X1
X$18979 \$4115 VSS VDD \$3905 CLKBUF_X1
X$18980 \$3958 VSS VDD \$4487 CLKBUF_X1
X$18981 \$4116 VSS VDD \$4115 CLKBUF_X1
X$18983 \$3905 VSS VDD \$3958 CLKBUF_X1
X$18984 \$4338 VSS VDD \$4787 CLKBUF_X1
X$18985 \$3662 VSS VDD \$3964 CLKBUF_X1
X$18986 \$3959 VSS VDD \$3752 CLKBUF_X1
X$18987 \$4125 VSS VDD \$4128 CLKBUF_X1
X$18988 \$1692 VSS VDD \$3244 CLKBUF_X3
X$18990 VSS \$3244 \$I100263 \$4144 \$3908 \$1304 VDD DFFR_X1
X$18991 VSS \$3244 \$I100260 \$4146 \$4035 \$1304 VDD DFFR_X1
X$18993 \$4255 VSS VDD \$3981 CLKBUF_X1
X$18994 VSS \$3074 \$I100526 \$3913 \$3981 \$1304 VDD DFFR_X1
X$18995 \$4037 VSS VDD \$4157 CLKBUF_X1
X$18996 \$3913 VSS VDD \$3914 CLKBUF_X1
X$18998 \$4573 VSS VDD \$4337 CLKBUF_X1
X$18999 \$4337 VSS VDD \$4338 CLKBUF_X1
X$19001 \$3964 VSS VDD \$3957 CLKBUF_X1
X$19003 \$4344 VSS VDD \$4125 CLKBUF_X1
X$19004 \$4128 VSS VDD \$4583 CLKBUF_X1
X$19005 \$4351 VSS VDD \$4138 CLKBUF_X1
X$19006 \$3670 VSS VDD \$4351 CLKBUF_X1
X$19007 \$3562 VSS VDD \$4142 CLKBUF_X1
X$19008 \$4144 VSS VDD \$4139 CLKBUF_X1
X$19009 \$4250 VSS VDD \$4035 CLKBUF_X1
X$19010 \$4357 VSS VDD \$4250 CLKBUF_X1
X$19011 \$4146 VSS VDD \$4252 CLKBUF_X1
X$19012 \$4254 VSS VDD \$4147 CLKBUF_X1
X$19013 VSS \$2862 \$I99944 \$4256 \$4036 \$1304 VDD DFFR_X1
X$19014 VSS \$3074 \$I100057 \$4370 \$4366 \$1304 VDD DFFR_X1
X$19015 VSS \$3074 \$I100044 \$4383 \$4372 \$3006 VDD DFFR_X1
X$19017 \$3985 VSS VDD \$4041 CLKBUF_X1
X$19018 \$3915 VSS VDD \$4377 CLKBUF_X1
X$19019 \$4040 VSS VDD \$4042 CLKBUF_X1
X$19020 \$4165 VSS VDD \$3915 CLKBUF_X1
X$19024 \$3995 VSS VDD \$3699 CLKBUF_X1
X$19026 \$3695 VSS VDD \$3995 CLKBUF_X1
X$19029 \$4384 VSS VDD \$4261 CLKBUF_X1
X$19030 \$4389 VSS VDD \$4262 CLKBUF_X1
X$19031 \$4261 VSS VDD \$4389 CLKBUF_X1
X$19034 \$4001 VSS VDD \$3834 CLKBUF_X1
X$19035 \$3919 VSS VDD \$4000 CLKBUF_X1
X$19036 \$4044 VSS VDD \$4392 CLKBUF_X1
X$19037 \$4007 VSS VDD \$4010 CLKBUF_X1
X$19038 \$4400 VSS VDD \$3920 CLKBUF_X1
X$19039 \$3920 VSS VDD \$4617 CLKBUF_X1
X$19041 \$4045 VSS VDD \$4829 CLKBUF_X1
X$19042 VSS \$3628 \$I100006 \$4505 \$4396 \$3833 VDD DFFR_X1
X$19043 \$4185 VSS VDD \$4046 CLKBUF_X1
X$19044 \$4015 VSS VDD \$4007 CLKBUF_X1
X$19045 \$4010 VSS VDD \$4185 CLKBUF_X1
X$19046 \$3921 VSS VDD \$4049 INV_X1
X$19047 \$4050 VSS VDD \$4051 CLKBUF_X1
X$19048 \$4006 VSS VDD \$4015 CLKBUF_X1
X$19051 \$191 VSS VDD \$I101710 INV_X2
X$19052 \$2886 VSS VDD \$191 CLKBUF_X3
X$19057 \$4407 VSS VDD \$4047 CLKBUF_X1
X$19058 \$4048 VSS VDD \$4407 CLKBUF_X1
X$19059 \$4047 VSS VDD \$4050 CLKBUF_X1
X$19060 \$4051 VSS VDD \$4409 CLKBUF_X1
X$19061 \$4409 VSS VDD \$4412 CLKBUF_X1
X$19062 \$4052 VSS VDD \$4411 CLKBUF_X1
X$19064 \$4624 VSS VDD \$4855 CLKBUF_X1
X$19065 \$4417 VSS VDD \$4265 CLKBUF_X1
X$19066 \$4266 VSS VDD \$4417 CLKBUF_X1
X$19067 \$4630 VSS VDD \$4416 CLKBUF_X1
X$19073 \$4420 VSS VDD \$4198 CLKBUF_X1
X$19075 \$4198 \$4708 \$3762 VDD VSS \$4028 HA_X1
X$19076 \$3721 VSS VDD \$3923 CLKBUF_X1
X$19077 \$3165 \$4055 \$3763 VSS VDD \$4057 NAND3_X1
X$19078 \$4056 \$3165 \$4055 \$3762 VSS VDD \$4058 NAND4_X1
X$19079 \$3767 \$4056 \$4273 VSS \$3731 VDD AOI21_X1
X$19080 \$3265 VSS VDD \$4216 CLKBUF_X1
X$19082 \$3769 VSS VDD \$4024 CLKBUF_X1
X$19083 \$4218 VSS VDD \$3769 INV_X1
X$19090 \$4055 VSS VDD \$3924 CLKBUF_X1
X$19091 \$4422 \$4272 \$4056 VDD VSS \$3767 HA_X1
X$19092 \$3771 \$4058 VSS VDD \$4434 OR2_X1
X$19093 \$4056 VSS VDD \$4218 CLKBUF_X1
X$19096 \$4442 VSS VDD \$2748 CLKBUF_X1
X$19099 \$4225 VSS VDD \$4223 CLKBUF_X1
X$19103 \$3230 VSS VDD \$4451 CLKBUF_X1
X$19104 \$4448 \$4276 VSS VDD \$4277 NAND2_X2
X$19105 \$701 VSS VDD \$4276 INV_X1
X$19106 \$4278 \$701 VSS VDD \$4449 NAND2_X2
X$19107 \$4278 VSS VDD \$4448 INV_X1
X$19110 \$887 \$4926 VSS VDD \$4278 XNOR2_X2
X$19111 \$4012 VSS VDD \$4232 CLKBUF_X1
X$19113 \$4232 VSS VDD \$4235 CLKBUF_X1
X$19114 \$4235 VSS VDD \$3894 CLKBUF_X1
X$19115 VSS \$2347 \$I100467 \$4460 \$3928 \$45 VDD DFFR_X1
X$19119 \$3774 VSS VDD \$4517 CLKBUF_X1
X$19120 \$4279 VSS VDD \$3928 CLKBUF_X1
X$19121 \$3929 VSS VDD \$4279 CLKBUF_X1
X$19123 \$4061 VSS VDD \$5161 CLKBUF_X1
X$19126 \$4463 VSS VDD \$4280 CLKBUF_X1
X$19127 \$3930 \$4466 \$4281 VDD VSS \$4468 HA_X1
X$19130 \$4471 VSS VDD \$4667 INV_X1
X$19131 \$3531 VSS VDD \$4283 INV_X1
X$19132 VSS \$4064 \$4471 \$4284 \$4063 \$4472 VDD FA_X1
X$19133 VSS \$4236 \$4472 \$4237 \$3019 \$4238 VDD FA_X1
X$19138 \$4237 VSS VDD \$4008 INV_X1
X$19142 \$2879 \$940 VSS VDD \$4526 NAND2_X1
X$19145 \$1171 VSS VDD \$4066 CLKBUF_X1
X$19147 \$3636 VSS VDD \$4236 INV_X1
X$19148 \$2756 \$1494 VSS VDD \$4478 NAND2_X1
X$19151 \$4478 VSS VDD \$4467 INV_X1
X$19155 \$1855 \$2184 VSS VDD \$4470 NAND2_X1
X$19159 \$4222 VSS VDD \$3884 CLKBUF_X1
X$19162 \$3933 VSS VDD \$4659 INV_X1
X$19163 \$4470 VSS VDD \$4285 INV_X1
X$19167 \$4067 VSS VDD \$4531 INV_X1
X$19170 \$726 \$3032 VSS VDD \$4289 NAND2_X1
X$19172 \$3934 VSS VDD \$4727 INV_X1
X$19174 \$2879 VSS VDD \$4222 CLKBUF_X1
X$19175 VSS \$3935 \$4217 \$4293 \$4215 \$3990 VDD FA_X1
X$19177 \$3936 VSS VDD \$3865 CLKBUF_X1
X$19178 \$2756 \$2359 VSS VDD \$3991 NAND2_X1
X$19179 \$1855 \$3032 VSS VDD \$4073 NAND2_X1
X$19180 \$3991 VSS VDD \$3990 INV_X1
X$19183 VSS \$2215 \$4294 \$2879 \$4071 \$327 VDD DFFR_X1
X$19185 \$3937 VSS VDD \$4436 INV_X1
X$19186 \$4073 VSS VDD \$4435 INV_X1
X$19187 \$2879 \$2359 VSS VDD \$4889 NAND2_X1
X$19190 \$4431 VSS VDD \$3988 CLKBUF_X1
X$19197 \$4638 VSS VDD \$3986 CLKBUF_X1
X$19198 VSS \$4075 \$I99905 \$726 \$4076 \$4734 VDD DFFR_X1
X$19203 \$4077 VSS VDD \$3539 INV_X1
X$19208 \$4298 \$4297 \$4077 VDD VSS \$4078 HA_X1
X$19209 \$4078 VSS VDD \$3938 INV_X1
X$19214 VSS \$4190 \$3789 \$3939 \$4195 \$3940 VDD FA_X1
X$19215 \$4191 VSS VDD \$3940 INV_X1
X$19216 VSS \$4543 \$4190 \$3682 \$4414 \$3983 VDD FA_X1
X$19217 \$4081 VSS VDD \$3983 INV_X1
X$19220 VSS \$3942 \$3941 \$3973 \$4187 \$4305 VDD FA_X1
X$19221 VSS \$4083 \$3978 \$3393 \$4181 \$3970 VDD FA_X1
X$19223 \$3944 VSS VDD \$4391 INV_X1
X$19224 \$4307 \$2083 VSS VDD \$3944 NAND2_X1
X$19226 \$4309 VSS VDD \$3299 INV_X1
X$19234 \$4301 VSS VDD \$4195 INV_X1
X$19237 VSS \$3038 \$4191 \$4081 \$3065 \$4303 VDD FA_X1
X$19242 \$4405 VSS VDD \$4187 INV_X1
X$19245 \$4390 VSS VDD \$4083 INV_X1
X$19248 \$4174 \$4391 \$3065 VDD VSS \$3038 HA_X1
X$19249 \$4307 \$2084 VSS VDD \$4084 NAND2_X1
X$19250 \$4084 VSS VDD \$4174 INV_X1
X$19252 \$1739 \$4085 VSS VDD \$3966 NOR2_X1
X$19254 VSS \$4170 \$3792 \$3302 \$3966 \$4088 VDD FA_X1
X$19255 \$4380 \$1739 VSS VDD \$3963 NAND2_X1
X$19259 \$4380 \$1735 VSS VDD \$4087 NAND2_X1
X$19260 \$4087 VSS VDD \$4170 INV_X1
X$19261 \$1902 \$2251 VSS VDD \$4089 NAND2_X1
X$19262 \$4089 VSS VDD \$4088 INV_X1
X$19264 \$4152 VSS VDD \$4095 CLKBUF_X1
X$19265 VSS \$3799 \$I100542 \$4093 \$4312 \$3947 VDD DFFR_X1
X$19266 \$4094 VSS VDD \$4149 CLKBUF_X1
X$19267 VSS \$3799 \$I100522 \$4101 \$4143 \$3947 VDD DFFR_X1
X$19268 VSS \$3794 \$I100488 \$2083 \$4117 \$3947 VDD DFFR_X1
X$19269 \$3952 VSS VDD \$3655 CLKBUF_X1
X$19271 \$750 VSS VDD \$3794 CLKBUF_X3
X$19272 \$3794 VSS VDD \$I101764 INV_X4
X$19281 \$4361 VSS VDD \$4313 CLKBUF_X1
X$19282 \$750 VSS VDD \$3799 CLKBUF_X3
X$19284 \$4149 VSS VDD \$3800 CLKBUF_X1
X$19285 \$4362 VSS VDD \$4094 CLKBUF_X1
X$19286 \$4093 VSS VDD \$4152 CLKBUF_X1
X$19287 \$4095 VSS VDD \$4362 CLKBUF_X1
X$19288 \$4345 VSS VDD \$4314 CLKBUF_X1
X$19289 \$4315 VSS VDD \$4317 CLKBUF_X1
X$19290 \$4097 VSS VDD \$4098 CLKBUF_X1
X$19291 \$4350 VSS VDD \$4143 CLKBUF_X1
X$19292 \$3948 VSS VDD \$4343 CLKBUF_X1
X$19293 \$4134 VSS VDD \$3652 CLKBUF_X1
X$19294 \$4343 VSS VDD \$4134 CLKBUF_X1
X$19295 \$3552 VSS VDD \$4099 CLKBUF_X1
X$19296 \$4101 VSS VDD \$4339 CLKBUF_X1
X$19297 \$4102 VSS VDD \$4320 CLKBUF_X1
X$19298 \$4319 VSS VDD \$4333 CLKBUF_X1
X$19299 \$4333 VSS VDD \$4117 CLKBUF_X1
X$19300 \$3653 VSS VDD \$4110 CLKBUF_X1
X$19301 \$3656 VSS VDD \$3654 CLKBUF_X1
.ENDS tf_lms_sv

.SUBCKT NAND3_X4 A2 A1 A3 VSS ZN VDD
M$1 ZN A3 VDD VDD PMOS_VTL L=0.05U W=2.52U AS=0.19845P AD=0.19845P PS=3.78U
+ PD=3.78U
M$2 VDD A2 ZN VDD PMOS_VTL L=0.05U W=2.52U AS=0.1764P AD=0.1764P PS=3.08U
+ PD=3.08U
M$3 ZN A1 VDD VDD PMOS_VTL L=0.05U W=2.52U AS=0.1764P AD=0.1764P PS=3.08U
+ PD=3.08U
M$13 \$15 A3 VSS VSS NMOS_VTL L=0.05U W=0.415U AS=0.043575P AD=0.02905P
+ PS=1.04U PD=0.555U
M$14 \$14 A2 \$15 VSS NMOS_VTL L=0.05U W=0.415U AS=0.02905P AD=0.02905P
+ PS=0.555U PD=0.555U
M$15 ZN A1 \$14 VSS NMOS_VTL L=0.05U W=0.415U AS=0.02905P AD=0.02905P PS=0.555U
+ PD=0.555U
M$16 \$12 A1 ZN VSS NMOS_VTL L=0.05U W=0.415U AS=0.02905P AD=0.02905P PS=0.555U
+ PD=0.555U
M$17 \$10 A2 \$12 VSS NMOS_VTL L=0.05U W=0.415U AS=0.02905P AD=0.02905P
+ PS=0.555U PD=0.555U
M$18 VSS A3 \$10 VSS NMOS_VTL L=0.05U W=0.415U AS=0.02905P AD=0.02905P
+ PS=0.555U PD=0.555U
M$19 \$11 A3 VSS VSS NMOS_VTL L=0.05U W=0.415U AS=0.02905P AD=0.02905P
+ PS=0.555U PD=0.555U
M$20 \$9 A2 \$11 VSS NMOS_VTL L=0.05U W=0.415U AS=0.02905P AD=0.02905P
+ PS=0.555U PD=0.555U
M$21 ZN A1 \$9 VSS NMOS_VTL L=0.05U W=0.415U AS=0.02905P AD=0.02905P PS=0.555U
+ PD=0.555U
M$22 \$16 A1 ZN VSS NMOS_VTL L=0.05U W=0.415U AS=0.02905P AD=0.02905P PS=0.555U
+ PD=0.555U
M$23 \$13 A2 \$16 VSS NMOS_VTL L=0.05U W=0.415U AS=0.02905P AD=0.02905P
+ PS=0.555U PD=0.555U
M$24 VSS A3 \$13 VSS NMOS_VTL L=0.05U W=0.415U AS=0.02905P AD=0.043575P
+ PS=0.555U PD=1.04U
.ENDS NAND3_X4

.SUBCKT AOI21_X4 VSS ZN A B2 B1 VDD
M$1 VDD A \$11 VDD PMOS_VTL L=0.05U W=2.52U AS=0.19845P AD=0.1764P PS=3.78U
+ PD=3.08U
M$5 ZN B2 \$11 VDD PMOS_VTL L=0.05U W=2.52U AS=0.1764P AD=0.19845P PS=3.08U
+ PD=3.78U
M$6 \$11 B1 ZN VDD PMOS_VTL L=0.05U W=2.52U AS=0.1764P AD=0.1764P PS=3.08U
+ PD=3.08U
M$13 ZN A VSS VSS NMOS_VTL L=0.05U W=1.66U AS=0.130725P AD=0.1162P PS=2.705U
+ PD=2.22U
M$17 \$8 B2 VSS VSS NMOS_VTL L=0.05U W=0.415U AS=0.02905P AD=0.02905P PS=0.555U
+ PD=0.555U
M$18 ZN B1 \$8 VSS NMOS_VTL L=0.05U W=0.415U AS=0.02905P AD=0.02905P PS=0.555U
+ PD=0.555U
M$19 \$9 B1 ZN VSS NMOS_VTL L=0.05U W=0.415U AS=0.02905P AD=0.02905P PS=0.555U
+ PD=0.555U
M$20 VSS B2 \$9 VSS NMOS_VTL L=0.05U W=0.415U AS=0.02905P AD=0.02905P PS=0.555U
+ PD=0.555U
M$21 \$6 B2 VSS VSS NMOS_VTL L=0.05U W=0.415U AS=0.02905P AD=0.02905P PS=0.555U
+ PD=0.555U
M$22 ZN B1 \$6 VSS NMOS_VTL L=0.05U W=0.415U AS=0.02905P AD=0.02905P PS=0.555U
+ PD=0.555U
M$23 \$7 B1 ZN VSS NMOS_VTL L=0.05U W=0.415U AS=0.02905P AD=0.02905P PS=0.555U
+ PD=0.555U
M$24 VSS B2 \$7 VSS NMOS_VTL L=0.05U W=0.415U AS=0.02905P AD=0.043575P
+ PS=0.555U PD=1.04U
.ENDS AOI21_X4

.SUBCKT AND4_X1 A1 A2 A3 A4 VDD VSS ZN
M$1 \$5 A1 VDD VDD PMOS_VTL L=0.05U W=0.315U AS=0.033075P AD=0.02205P PS=0.84U
+ PD=0.455U
M$2 VDD A2 \$5 VDD PMOS_VTL L=0.05U W=0.315U AS=0.02205P AD=0.02205P PS=0.455U
+ PD=0.455U
M$3 \$5 A3 VDD VDD PMOS_VTL L=0.05U W=0.315U AS=0.02205P AD=0.02205P PS=0.455U
+ PD=0.455U
M$4 \$5 A4 VDD VDD PMOS_VTL L=0.05U W=0.315U AS=0.033075P AD=0.02205P PS=0.77U
+ PD=0.455U
M$5 ZN \$5 VDD VDD PMOS_VTL L=0.05U W=0.63U AS=0.033075P AD=0.06615P PS=0.77U
+ PD=1.47U
M$6 \$12 A1 \$5 VSS NMOS_VTL L=0.05U W=0.21U AS=0.02205P AD=0.0147P PS=0.63U
+ PD=0.35U
M$7 \$13 A2 \$12 VSS NMOS_VTL L=0.05U W=0.21U AS=0.0147P AD=0.0147P PS=0.35U
+ PD=0.35U
M$8 \$11 A3 \$13 VSS NMOS_VTL L=0.05U W=0.21U AS=0.0147P AD=0.0147P PS=0.35U
+ PD=0.35U
M$9 VSS A4 \$11 VSS NMOS_VTL L=0.05U W=0.21U AS=0.0147P AD=0.021875P PS=0.35U
+ PD=0.555U
M$10 ZN \$5 VSS VSS NMOS_VTL L=0.05U W=0.415U AS=0.021875P AD=0.043575P
+ PS=0.555U PD=1.04U
.ENDS AND4_X1

.SUBCKT BUF_X4 A VDD Z VSS
M$1 \$2 A VDD VDD PMOS_VTL L=0.05U W=1.26U AS=0.11025P AD=0.0882P PS=2.24U
+ PD=1.54U
M$3 Z \$2 VDD VDD PMOS_VTL L=0.05U W=2.52U AS=0.1764P AD=0.19845P PS=3.08U
+ PD=3.78U
M$7 \$2 A VSS VSS NMOS_VTL L=0.05U W=0.83U AS=0.072625P AD=0.0581P PS=1.595U
+ PD=1.11U
M$9 Z \$2 VSS VSS NMOS_VTL L=0.05U W=1.66U AS=0.1162P AD=0.130725P PS=2.22U
+ PD=2.705U
.ENDS BUF_X4

.SUBCKT AND3_X1 A1 A2 A3 VDD VSS ZN
M$1 VDD A1 \$4 VDD PMOS_VTL L=0.05U W=0.315U AS=0.033075P AD=0.02205P PS=0.84U
+ PD=0.455U
M$2 \$4 A2 VDD VDD PMOS_VTL L=0.05U W=0.315U AS=0.02205P AD=0.02205P PS=0.455U
+ PD=0.455U
M$3 \$4 A3 VDD VDD PMOS_VTL L=0.05U W=0.315U AS=0.033075P AD=0.02205P PS=0.77U
+ PD=0.455U
M$4 ZN \$4 VDD VDD PMOS_VTL L=0.05U W=0.63U AS=0.033075P AD=0.06615P PS=0.77U
+ PD=1.47U
M$5 \$10 A1 \$4 VSS NMOS_VTL L=0.05U W=0.21U AS=0.02205P AD=0.0147P PS=0.63U
+ PD=0.35U
M$6 \$11 A2 \$10 VSS NMOS_VTL L=0.05U W=0.21U AS=0.0147P AD=0.0147P PS=0.35U
+ PD=0.35U
M$7 VSS A3 \$11 VSS NMOS_VTL L=0.05U W=0.21U AS=0.0147P AD=0.021875P PS=0.35U
+ PD=0.555U
M$8 ZN \$4 VSS VSS NMOS_VTL L=0.05U W=0.415U AS=0.021875P AD=0.043575P
+ PS=0.555U PD=1.04U
.ENDS AND3_X1

.SUBCKT XOR2_X2 B A VDD Z VSS
M$1 \$10 A \$3 VDD PMOS_VTL L=0.05U W=0.63U AS=0.06615P AD=0.0441P PS=1.47U
+ PD=0.77U
M$2 VDD B \$10 VDD PMOS_VTL L=0.05U W=0.63U AS=0.0441P AD=0.0441P PS=0.77U
+ PD=0.77U
M$3 \$6 \$3 VDD VDD PMOS_VTL L=0.05U W=1.26U AS=0.0882P AD=0.11025P PS=1.54U
+ PD=2.24U
M$4 Z A \$6 VDD PMOS_VTL L=0.05U W=1.26U AS=0.0882P AD=0.0882P PS=1.54U PD=1.54U
M$5 \$6 B Z VDD PMOS_VTL L=0.05U W=1.26U AS=0.0882P AD=0.0882P PS=1.54U PD=1.54U
M$9 \$3 A VSS VSS NMOS_VTL L=0.05U W=0.415U AS=0.043575P AD=0.02905P PS=1.04U
+ PD=0.555U
M$10 VSS B \$3 VSS NMOS_VTL L=0.05U W=0.415U AS=0.02905P AD=0.02905P PS=0.555U
+ PD=0.555U
M$11 Z \$3 VSS VSS NMOS_VTL L=0.05U W=0.83U AS=0.0581P AD=0.072625P PS=1.11U
+ PD=1.595U
M$12 \$12 A Z VSS NMOS_VTL L=0.05U W=0.415U AS=0.02905P AD=0.02905P PS=0.555U
+ PD=0.555U
M$13 VSS B \$12 VSS NMOS_VTL L=0.05U W=0.415U AS=0.02905P AD=0.02905P PS=0.555U
+ PD=0.555U
M$14 \$11 B VSS VSS NMOS_VTL L=0.05U W=0.415U AS=0.02905P AD=0.02905P PS=0.555U
+ PD=0.555U
M$15 Z A \$11 VSS NMOS_VTL L=0.05U W=0.415U AS=0.02905P AD=0.02905P PS=0.555U
+ PD=0.555U
.ENDS XOR2_X2

.SUBCKT NOR3_X4 VSS A1 A2 A3 ZN VDD
M$1 ZN A1 \$8 VDD PMOS_VTL L=0.05U W=2.52U AS=0.19845P AD=0.1764P PS=3.78U
+ PD=3.08U
M$5 \$6 A2 \$8 VDD PMOS_VTL L=0.05U W=2.52U AS=0.1764P AD=0.19845P PS=3.08U
+ PD=3.78U
M$9 \$6 A3 VDD VDD PMOS_VTL L=0.05U W=2.52U AS=0.19845P AD=0.19845P PS=3.78U
+ PD=3.78U
M$13 ZN A1 VSS VSS NMOS_VTL L=0.05U W=1.66U AS=0.130725P AD=0.1162P PS=2.705U
+ PD=2.22U
M$17 ZN A2 VSS VSS NMOS_VTL L=0.05U W=1.66U AS=0.1162P AD=0.130725P PS=2.22U
+ PD=2.705U
M$21 ZN A3 VSS VSS NMOS_VTL L=0.05U W=1.66U AS=0.130725P AD=0.130725P PS=2.705U
+ PD=2.705U
.ENDS NOR3_X4

.SUBCKT OR2_X4 A2 A1 VSS ZN VDD
M$1 \$10 A2 VDD VDD PMOS_VTL L=0.05U W=0.63U AS=0.06615P AD=0.0441P PS=1.47U
+ PD=0.77U
M$2 \$4 A1 \$10 VDD PMOS_VTL L=0.05U W=0.63U AS=0.0441P AD=0.0441P PS=0.77U
+ PD=0.77U
M$3 \$9 A1 \$4 VDD PMOS_VTL L=0.05U W=0.63U AS=0.0441P AD=0.0441P PS=0.77U
+ PD=0.77U
M$4 VDD A2 \$9 VDD PMOS_VTL L=0.05U W=0.63U AS=0.0441P AD=0.0441P PS=0.77U
+ PD=0.77U
M$5 ZN \$4 VDD VDD PMOS_VTL L=0.05U W=2.52U AS=0.1764P AD=0.19845P PS=3.08U
+ PD=3.78U
M$9 \$4 A2 VSS VSS NMOS_VTL L=0.05U W=0.83U AS=0.072625P AD=0.0581P PS=1.595U
+ PD=1.11U
M$10 VSS A1 \$4 VSS NMOS_VTL L=0.05U W=0.83U AS=0.0581P AD=0.0581P PS=1.11U
+ PD=1.11U
M$13 ZN \$4 VSS VSS NMOS_VTL L=0.05U W=1.66U AS=0.1162P AD=0.130725P PS=2.22U
+ PD=2.705U
.ENDS OR2_X4

.SUBCKT NOR4_X4 VSS A1 A2 A3 A4 ZN VDD
M$1 \$9 A3 \$10 VDD PMOS_VTL L=0.05U W=2.52U AS=0.19845P AD=0.1764P PS=3.78U
+ PD=3.08U
M$5 VDD A4 \$10 VDD PMOS_VTL L=0.05U W=2.52U AS=0.1764P AD=0.19845P PS=3.08U
+ PD=3.78U
M$9 ZN A1 \$8 VDD PMOS_VTL L=0.05U W=2.52U AS=0.19845P AD=0.1764P PS=3.78U
+ PD=3.08U
M$13 \$9 A2 \$8 VDD PMOS_VTL L=0.05U W=2.52U AS=0.1764P AD=0.19845P PS=3.08U
+ PD=3.78U
M$17 VSS A3 ZN VSS NMOS_VTL L=0.05U W=1.66U AS=0.130725P AD=0.1162P PS=2.705U
+ PD=2.22U
M$21 VSS A4 ZN VSS NMOS_VTL L=0.05U W=1.66U AS=0.1162P AD=0.130725P PS=2.22U
+ PD=2.705U
M$25 ZN A1 VSS VSS NMOS_VTL L=0.05U W=1.66U AS=0.130725P AD=0.1162P PS=2.705U
+ PD=2.22U
M$29 ZN A2 VSS VSS NMOS_VTL L=0.05U W=1.66U AS=0.1162P AD=0.130725P PS=2.22U
+ PD=2.705U
.ENDS NOR4_X4

.SUBCKT NOR4_X2 A3 A2 A1 A4 VDD ZN VSS
M$1 \$14 A4 VDD VDD PMOS_VTL L=0.05U W=0.63U AS=0.06615P AD=0.0441P PS=1.47U
+ PD=0.77U
M$2 \$13 A3 \$14 VDD PMOS_VTL L=0.05U W=0.63U AS=0.0441P AD=0.0441P PS=0.77U
+ PD=0.77U
M$3 \$12 A2 \$13 VDD PMOS_VTL L=0.05U W=0.63U AS=0.0441P AD=0.0441P PS=0.77U
+ PD=0.77U
M$4 ZN A1 \$12 VDD PMOS_VTL L=0.05U W=0.63U AS=0.0441P AD=0.0441P PS=0.77U
+ PD=0.77U
M$5 \$11 A1 ZN VDD PMOS_VTL L=0.05U W=0.63U AS=0.0441P AD=0.0441P PS=0.77U
+ PD=0.77U
M$6 \$15 A2 \$11 VDD PMOS_VTL L=0.05U W=0.63U AS=0.0441P AD=0.0441P PS=0.77U
+ PD=0.77U
M$7 \$10 A3 \$15 VDD PMOS_VTL L=0.05U W=0.63U AS=0.0441P AD=0.0441P PS=0.77U
+ PD=0.77U
M$8 VDD A4 \$10 VDD PMOS_VTL L=0.05U W=0.63U AS=0.0441P AD=0.06615P PS=0.77U
+ PD=1.47U
M$9 ZN A4 VSS VSS NMOS_VTL L=0.05U W=0.83U AS=0.072625P AD=0.072625P PS=1.595U
+ PD=1.595U
M$10 VSS A3 ZN VSS NMOS_VTL L=0.05U W=0.83U AS=0.0581P AD=0.0581P PS=1.11U
+ PD=1.11U
M$11 ZN A2 VSS VSS NMOS_VTL L=0.05U W=0.83U AS=0.0581P AD=0.0581P PS=1.11U
+ PD=1.11U
M$12 VSS A1 ZN VSS NMOS_VTL L=0.05U W=0.83U AS=0.0581P AD=0.0581P PS=1.11U
+ PD=1.11U
.ENDS NOR4_X2

.SUBCKT AND2_X4 A2 A1 VDD ZN VSS
M$1 \$3 A2 VDD VDD PMOS_VTL L=0.05U W=1.26U AS=0.11025P AD=0.0882P PS=2.24U
+ PD=1.54U
M$2 VDD A1 \$3 VDD PMOS_VTL L=0.05U W=1.26U AS=0.0882P AD=0.0882P PS=1.54U
+ PD=1.54U
M$5 ZN \$3 VDD VDD PMOS_VTL L=0.05U W=2.52U AS=0.1764P AD=0.19845P PS=3.08U
+ PD=3.78U
M$9 \$10 A2 VSS VSS NMOS_VTL L=0.05U W=0.415U AS=0.043575P AD=0.02905P PS=1.04U
+ PD=0.555U
M$10 \$3 A1 \$10 VSS NMOS_VTL L=0.05U W=0.415U AS=0.02905P AD=0.02905P
+ PS=0.555U PD=0.555U
M$11 \$9 A1 \$3 VSS NMOS_VTL L=0.05U W=0.415U AS=0.02905P AD=0.02905P PS=0.555U
+ PD=0.555U
M$12 VSS A2 \$9 VSS NMOS_VTL L=0.05U W=0.415U AS=0.02905P AD=0.02905P PS=0.555U
+ PD=0.555U
M$13 ZN \$3 VSS VSS NMOS_VTL L=0.05U W=1.66U AS=0.1162P AD=0.130725P PS=2.22U
+ PD=2.705U
.ENDS AND2_X4

.SUBCKT NAND4_X4 VSS A3 A4 A1 A2 ZN VDD
M$1 VDD A1 ZN VDD PMOS_VTL L=0.05U W=2.52U AS=0.19845P AD=0.1764P PS=3.78U
+ PD=3.08U
M$5 VDD A2 ZN VDD PMOS_VTL L=0.05U W=2.52U AS=0.1764P AD=0.22365P PS=3.08U
+ PD=3.23U
M$9 VDD A3 ZN VDD PMOS_VTL L=0.05U W=2.52U AS=0.22365P AD=0.1764P PS=3.23U
+ PD=3.08U
M$13 VDD A4 ZN VDD PMOS_VTL L=0.05U W=2.52U AS=0.1764P AD=0.19845P PS=3.08U
+ PD=3.78U
M$17 \$5 A3 \$6 VSS NMOS_VTL L=0.05U W=1.66U AS=0.130725P AD=0.1162P PS=2.705U
+ PD=2.22U
M$21 VSS A4 \$6 VSS NMOS_VTL L=0.05U W=1.66U AS=0.1162P AD=0.130725P PS=2.22U
+ PD=2.705U
M$25 ZN A1 \$4 VSS NMOS_VTL L=0.05U W=1.66U AS=0.130725P AD=0.1162P PS=2.705U
+ PD=2.22U
M$29 \$5 A2 \$4 VSS NMOS_VTL L=0.05U W=1.66U AS=0.1162P AD=0.130725P PS=2.22U
+ PD=2.705U
.ENDS NAND4_X4

.SUBCKT INV_X8 A VSS VDD
M$1 ZN A VDD VDD PMOS_VTL L=0.05U W=5.04U AS=0.37485P AD=0.37485P PS=6.86U
+ PD=6.86U
M$9 ZN A VSS VSS NMOS_VTL L=0.05U W=3.32U AS=0.246925P AD=0.246925P PS=4.925U
+ PD=4.925U
.ENDS INV_X8

.SUBCKT OAI21_X4 A B2 B1 VDD VSS ZN
M$1 ZN A VDD VDD PMOS_VTL L=0.05U W=2.52U AS=0.19845P AD=0.1764P PS=3.78U
+ PD=3.08U
M$5 \$13 B2 VDD VDD PMOS_VTL L=0.05U W=0.63U AS=0.0441P AD=0.0441P PS=0.77U
+ PD=0.77U
M$6 ZN B1 \$13 VDD PMOS_VTL L=0.05U W=0.63U AS=0.0441P AD=0.0441P PS=0.77U
+ PD=0.77U
M$7 \$12 B1 ZN VDD PMOS_VTL L=0.05U W=0.63U AS=0.0441P AD=0.0441P PS=0.77U
+ PD=0.77U
M$8 VDD B2 \$12 VDD PMOS_VTL L=0.05U W=0.63U AS=0.0441P AD=0.0441P PS=0.77U
+ PD=0.77U
M$9 \$11 B2 VDD VDD PMOS_VTL L=0.05U W=0.63U AS=0.0441P AD=0.0441P PS=0.77U
+ PD=0.77U
M$10 ZN B1 \$11 VDD PMOS_VTL L=0.05U W=0.63U AS=0.0441P AD=0.0441P PS=0.77U
+ PD=0.77U
M$11 \$10 B1 ZN VDD PMOS_VTL L=0.05U W=0.63U AS=0.0441P AD=0.0441P PS=0.77U
+ PD=0.77U
M$12 VDD B2 \$10 VDD PMOS_VTL L=0.05U W=0.63U AS=0.0441P AD=0.06615P PS=0.77U
+ PD=1.47U
M$13 VSS A \$4 VSS NMOS_VTL L=0.05U W=1.66U AS=0.130725P AD=0.1162P PS=2.705U
+ PD=2.22U
M$17 ZN B2 \$4 VSS NMOS_VTL L=0.05U W=1.66U AS=0.1162P AD=0.130725P PS=2.22U
+ PD=2.705U
M$18 \$4 B1 ZN VSS NMOS_VTL L=0.05U W=1.66U AS=0.1162P AD=0.1162P PS=2.22U
+ PD=2.22U
.ENDS OAI21_X4

.SUBCKT BUF_X2 A VSS VDD Z
M$1 VDD A \$2 VDD PMOS_VTL L=0.05U W=0.63U AS=0.06615P AD=0.0441P PS=1.47U
+ PD=0.77U
M$2 Z \$2 VDD VDD PMOS_VTL L=0.05U W=1.26U AS=0.0882P AD=0.11025P PS=1.54U
+ PD=2.24U
M$4 VSS A \$2 VSS NMOS_VTL L=0.05U W=0.415U AS=0.043575P AD=0.02905P PS=1.04U
+ PD=0.555U
M$5 Z \$2 VSS VSS NMOS_VTL L=0.05U W=0.83U AS=0.0581P AD=0.072625P PS=1.11U
+ PD=1.595U
.ENDS BUF_X2

.SUBCKT XNOR2_X2 A B VSS VDD ZN
M$1 ZN A \$8 VDD PMOS_VTL L=0.05U W=0.63U AS=0.06615P AD=0.0441P PS=1.47U
+ PD=0.77U
M$2 \$11 A ZN VDD PMOS_VTL L=0.05U W=0.63U AS=0.0441P AD=0.0441P PS=0.77U
+ PD=0.77U
M$3 VDD B \$11 VDD PMOS_VTL L=0.05U W=0.63U AS=0.0441P AD=0.0441P PS=0.77U
+ PD=0.77U
M$4 \$8 B VDD VDD PMOS_VTL L=0.05U W=0.63U AS=0.0441P AD=0.06615P PS=0.77U
+ PD=1.47U
M$5 ZN \$1 VDD VDD PMOS_VTL L=0.05U W=1.26U AS=0.11025P AD=0.0882P PS=2.24U
+ PD=1.54U
M$7 \$1 B VDD VDD PMOS_VTL L=0.05U W=0.63U AS=0.0441P AD=0.0441P PS=0.77U
+ PD=0.77U
M$8 VDD A \$1 VDD PMOS_VTL L=0.05U W=0.63U AS=0.0441P AD=0.06615P PS=0.77U
+ PD=1.47U
M$9 \$6 A ZN VSS NMOS_VTL L=0.05U W=0.83U AS=0.072625P AD=0.0581P PS=1.595U
+ PD=1.11U
M$11 \$6 B ZN VSS NMOS_VTL L=0.05U W=0.83U AS=0.0581P AD=0.072625P PS=1.11U
+ PD=1.595U
M$13 \$6 \$1 VSS VSS NMOS_VTL L=0.05U W=0.83U AS=0.072625P AD=0.0581P PS=1.595U
+ PD=1.11U
M$15 \$12 B VSS VSS NMOS_VTL L=0.05U W=0.415U AS=0.02905P AD=0.02905P PS=0.555U
+ PD=0.555U
M$16 \$1 A \$12 VSS NMOS_VTL L=0.05U W=0.415U AS=0.02905P AD=0.043575P
+ PS=0.555U PD=1.04U
.ENDS XNOR2_X2

.SUBCKT NAND3_X2 A3 A2 A1 VSS VDD ZN
M$1 ZN A3 VDD VDD PMOS_VTL L=0.05U W=1.26U AS=0.11025P AD=0.11025P PS=2.24U
+ PD=2.24U
M$2 VDD A2 ZN VDD PMOS_VTL L=0.05U W=1.26U AS=0.0882P AD=0.0882P PS=1.54U
+ PD=1.54U
M$3 ZN A1 VDD VDD PMOS_VTL L=0.05U W=1.26U AS=0.0882P AD=0.0882P PS=1.54U
+ PD=1.54U
M$7 \$12 A3 VSS VSS NMOS_VTL L=0.05U W=0.415U AS=0.043575P AD=0.02905P PS=1.04U
+ PD=0.555U
M$8 \$11 A2 \$12 VSS NMOS_VTL L=0.05U W=0.415U AS=0.02905P AD=0.02905P
+ PS=0.555U PD=0.555U
M$9 ZN A1 \$11 VSS NMOS_VTL L=0.05U W=0.415U AS=0.02905P AD=0.02905P PS=0.555U
+ PD=0.555U
M$10 \$10 A1 ZN VSS NMOS_VTL L=0.05U W=0.415U AS=0.02905P AD=0.02905P PS=0.555U
+ PD=0.555U
M$11 \$9 A2 \$10 VSS NMOS_VTL L=0.05U W=0.415U AS=0.02905P AD=0.02905P
+ PS=0.555U PD=0.555U
M$12 VSS A3 \$9 VSS NMOS_VTL L=0.05U W=0.415U AS=0.02905P AD=0.043575P
+ PS=0.555U PD=1.04U
.ENDS NAND3_X2

.SUBCKT OAI21_X2 A B2 B1 VDD VSS ZN
M$1 ZN A VDD VDD PMOS_VTL L=0.05U W=1.26U AS=0.11025P AD=0.0882P PS=2.24U
+ PD=1.54U
M$3 \$10 B2 VDD VDD PMOS_VTL L=0.05U W=0.63U AS=0.0441P AD=0.0441P PS=0.77U
+ PD=0.77U
M$4 ZN B1 \$10 VDD PMOS_VTL L=0.05U W=0.63U AS=0.0441P AD=0.0441P PS=0.77U
+ PD=0.77U
M$5 \$11 B1 ZN VDD PMOS_VTL L=0.05U W=0.63U AS=0.0441P AD=0.0441P PS=0.77U
+ PD=0.77U
M$6 VDD B2 \$11 VDD PMOS_VTL L=0.05U W=0.63U AS=0.0441P AD=0.06615P PS=0.77U
+ PD=1.47U
M$7 VSS A \$4 VSS NMOS_VTL L=0.05U W=0.83U AS=0.072625P AD=0.0581P PS=1.595U
+ PD=1.11U
M$9 ZN B2 \$4 VSS NMOS_VTL L=0.05U W=0.83U AS=0.0581P AD=0.072625P PS=1.11U
+ PD=1.595U
M$10 \$4 B1 ZN VSS NMOS_VTL L=0.05U W=0.83U AS=0.0581P AD=0.0581P PS=1.11U
+ PD=1.11U
.ENDS OAI21_X2

.SUBCKT NOR4_X1 A4 A3 A2 A1 VSS VDD ZN
M$1 \$12 A4 VDD VDD PMOS_VTL L=0.05U W=0.63U AS=0.06615P AD=0.0441P PS=1.47U
+ PD=0.77U
M$2 \$11 A3 \$12 VDD PMOS_VTL L=0.05U W=0.63U AS=0.0441P AD=0.0441P PS=0.77U
+ PD=0.77U
M$3 \$10 A2 \$11 VDD PMOS_VTL L=0.05U W=0.63U AS=0.0441P AD=0.0441P PS=0.77U
+ PD=0.77U
M$4 ZN A1 \$10 VDD PMOS_VTL L=0.05U W=0.63U AS=0.0441P AD=0.06615P PS=0.77U
+ PD=1.47U
M$5 ZN A4 VSS VSS NMOS_VTL L=0.05U W=0.415U AS=0.043575P AD=0.02905P PS=1.04U
+ PD=0.555U
M$6 VSS A3 ZN VSS NMOS_VTL L=0.05U W=0.415U AS=0.02905P AD=0.02905P PS=0.555U
+ PD=0.555U
M$7 ZN A2 VSS VSS NMOS_VTL L=0.05U W=0.415U AS=0.02905P AD=0.02905P PS=0.555U
+ PD=0.555U
M$8 VSS A1 ZN VSS NMOS_VTL L=0.05U W=0.415U AS=0.02905P AD=0.043575P PS=0.555U
+ PD=1.04U
.ENDS NOR4_X1

.SUBCKT NAND2_X2 A2 A1 VSS VDD ZN
M$1 ZN A2 VDD VDD PMOS_VTL L=0.05U W=1.26U AS=0.11025P AD=0.11025P PS=2.24U
+ PD=2.24U
M$2 VDD A1 ZN VDD PMOS_VTL L=0.05U W=1.26U AS=0.0882P AD=0.0882P PS=1.54U
+ PD=1.54U
M$5 \$9 A2 VSS VSS NMOS_VTL L=0.05U W=0.415U AS=0.043575P AD=0.02905P PS=1.04U
+ PD=0.555U
M$6 ZN A1 \$9 VSS NMOS_VTL L=0.05U W=0.415U AS=0.02905P AD=0.02905P PS=0.555U
+ PD=0.555U
M$7 \$8 A1 ZN VSS NMOS_VTL L=0.05U W=0.415U AS=0.02905P AD=0.02905P PS=0.555U
+ PD=0.555U
M$8 VSS A2 \$8 VSS NMOS_VTL L=0.05U W=0.415U AS=0.02905P AD=0.043575P PS=0.555U
+ PD=1.04U
.ENDS NAND2_X2

.SUBCKT NAND2_X4 A2 A1 VSS ZN VDD
M$1 ZN A2 VDD VDD PMOS_VTL L=0.05U W=2.52U AS=0.19845P AD=0.1764P PS=3.78U
+ PD=3.08U
M$5 ZN A1 VDD VDD PMOS_VTL L=0.05U W=2.52U AS=0.1764P AD=0.19845P PS=3.08U
+ PD=3.78U
M$9 VSS A2 \$3 VSS NMOS_VTL L=0.05U W=1.66U AS=0.130725P AD=0.1162P PS=2.705U
+ PD=2.22U
M$13 ZN A1 \$3 VSS NMOS_VTL L=0.05U W=1.66U AS=0.1162P AD=0.130725P PS=2.22U
+ PD=2.705U
.ENDS NAND2_X4

.SUBCKT INV_X2 A VSS VDD ZN
M$1 ZN A VDD VDD PMOS_VTL L=0.05U W=1.26U AS=0.11025P AD=0.11025P PS=2.24U
+ PD=2.24U
M$3 ZN A VSS VSS NMOS_VTL L=0.05U W=0.83U AS=0.072625P AD=0.072625P PS=1.595U
+ PD=1.595U
.ENDS INV_X2

.SUBCKT INV_X4 A VSS VDD ZN
M$1 ZN A VDD VDD PMOS_VTL L=0.05U W=2.52U AS=0.19845P AD=0.19845P PS=3.78U
+ PD=3.78U
M$5 ZN A VSS VSS NMOS_VTL L=0.05U W=1.66U AS=0.130725P AD=0.130725P PS=2.705U
+ PD=2.705U
.ENDS INV_X4

.SUBCKT NOR2_X2 A2 A1 VSS VDD ZN
M$1 \$9 A2 VDD VDD PMOS_VTL L=0.05U W=0.63U AS=0.06615P AD=0.0441P PS=1.47U
+ PD=0.77U
M$2 ZN A1 \$9 VDD PMOS_VTL L=0.05U W=0.63U AS=0.0441P AD=0.0441P PS=0.77U
+ PD=0.77U
M$3 \$8 A1 ZN VDD PMOS_VTL L=0.05U W=0.63U AS=0.0441P AD=0.0441P PS=0.77U
+ PD=0.77U
M$4 VDD A2 \$8 VDD PMOS_VTL L=0.05U W=0.63U AS=0.0441P AD=0.06615P PS=0.77U
+ PD=1.47U
M$5 ZN A2 VSS VSS NMOS_VTL L=0.05U W=0.83U AS=0.072625P AD=0.072625P PS=1.595U
+ PD=1.595U
M$6 VSS A1 ZN VSS NMOS_VTL L=0.05U W=0.83U AS=0.0581P AD=0.0581P PS=1.11U
+ PD=1.11U
.ENDS NOR2_X2

.SUBCKT OAI221_X1 B2 B1 A C2 C1 VDD VSS ZN
M$1 \$14 B2 VDD VDD PMOS_VTL L=0.05U W=0.63U AS=0.06615P AD=0.0441P PS=1.47U
+ PD=0.77U
M$2 ZN B1 \$14 VDD PMOS_VTL L=0.05U W=0.63U AS=0.0441P AD=0.0441P PS=0.77U
+ PD=0.77U
M$3 VDD A ZN VDD PMOS_VTL L=0.05U W=0.63U AS=0.0441P AD=0.0441P PS=0.77U
+ PD=0.77U
M$4 \$13 C2 VDD VDD PMOS_VTL L=0.05U W=0.63U AS=0.0441P AD=0.0441P PS=0.77U
+ PD=0.77U
M$5 ZN C1 \$13 VDD PMOS_VTL L=0.05U W=0.63U AS=0.0441P AD=0.06615P PS=0.77U
+ PD=1.47U
M$6 VSS B2 \$6 VSS NMOS_VTL L=0.05U W=0.415U AS=0.043575P AD=0.02905P PS=1.04U
+ PD=0.555U
M$7 \$6 B1 VSS VSS NMOS_VTL L=0.05U W=0.415U AS=0.02905P AD=0.02905P PS=0.555U
+ PD=0.555U
M$8 \$10 A \$6 VSS NMOS_VTL L=0.05U W=0.415U AS=0.02905P AD=0.02905P PS=0.555U
+ PD=0.555U
M$9 ZN C2 \$10 VSS NMOS_VTL L=0.05U W=0.415U AS=0.02905P AD=0.02905P PS=0.555U
+ PD=0.555U
M$10 \$10 C1 ZN VSS NMOS_VTL L=0.05U W=0.415U AS=0.02905P AD=0.043575P
+ PS=0.555U PD=1.04U
.ENDS OAI221_X1

.SUBCKT NOR2_X4 A2 A1 ZN VSS VDD
M$1 \$11 A2 VDD VDD PMOS_VTL L=0.05U W=0.63U AS=0.06615P AD=0.0441P PS=1.47U
+ PD=0.77U
M$2 ZN A1 \$11 VDD PMOS_VTL L=0.05U W=0.63U AS=0.0441P AD=0.0441P PS=0.77U
+ PD=0.77U
M$3 \$10 A1 ZN VDD PMOS_VTL L=0.05U W=0.63U AS=0.0441P AD=0.0441P PS=0.77U
+ PD=0.77U
M$4 VDD A2 \$10 VDD PMOS_VTL L=0.05U W=0.63U AS=0.0441P AD=0.0441P PS=0.77U
+ PD=0.77U
M$5 \$9 A2 VDD VDD PMOS_VTL L=0.05U W=0.63U AS=0.0441P AD=0.0441P PS=0.77U
+ PD=0.77U
M$6 ZN A1 \$9 VDD PMOS_VTL L=0.05U W=0.63U AS=0.0441P AD=0.0441P PS=0.77U
+ PD=0.77U
M$7 \$8 A1 ZN VDD PMOS_VTL L=0.05U W=0.63U AS=0.0441P AD=0.0441P PS=0.77U
+ PD=0.77U
M$8 VDD A2 \$8 VDD PMOS_VTL L=0.05U W=0.63U AS=0.0441P AD=0.06615P PS=0.77U
+ PD=1.47U
M$9 ZN A2 VSS VSS NMOS_VTL L=0.05U W=1.66U AS=0.130725P AD=0.130725P PS=2.705U
+ PD=2.705U
M$10 VSS A1 ZN VSS NMOS_VTL L=0.05U W=1.66U AS=0.1162P AD=0.1162P PS=2.22U
+ PD=2.22U
.ENDS NOR2_X4

.SUBCKT BUF_X1 A VSS VDD Z
M$1 \$2 A VDD VDD PMOS_VTL L=0.05U W=0.315U AS=0.033075P AD=0.033075P PS=0.77U
+ PD=0.84U
M$2 Z \$2 VDD VDD PMOS_VTL L=0.05U W=0.63U AS=0.033075P AD=0.06615P PS=0.77U
+ PD=1.47U
M$3 VSS A \$2 VSS NMOS_VTL L=0.05U W=0.21U AS=0.02205P AD=0.021875P PS=0.63U
+ PD=0.555U
M$4 Z \$2 VSS VSS NMOS_VTL L=0.05U W=0.415U AS=0.021875P AD=0.043575P PS=0.555U
+ PD=1.04U
.ENDS BUF_X1

.SUBCKT CLKBUF_X1 A VSS VDD Z
M$1 \$2 A VDD VDD PMOS_VTL L=0.05U W=0.315U AS=0.033075P AD=0.033075P PS=0.77U
+ PD=0.84U
M$2 Z \$2 VDD VDD PMOS_VTL L=0.05U W=0.63U AS=0.033075P AD=0.06615P PS=0.77U
+ PD=1.47U
M$3 VSS A \$2 VSS NMOS_VTL L=0.05U W=0.095U AS=0.009975P AD=0.01015P PS=0.4U
+ PD=0.335U
M$4 Z \$2 VSS VSS NMOS_VTL L=0.05U W=0.195U AS=0.01015P AD=0.020475P PS=0.335U
+ PD=0.6U
.ENDS CLKBUF_X1

.SUBCKT CLKBUF_X3 A VSS VDD Z
M$1 VDD A \$2 VDD PMOS_VTL L=0.05U W=0.63U AS=0.06615P AD=0.0441P PS=1.47U
+ PD=0.77U
M$2 Z \$2 VDD VDD PMOS_VTL L=0.05U W=1.89U AS=0.1323P AD=0.15435P PS=2.31U
+ PD=3.01U
M$5 VSS A \$2 VSS NMOS_VTL L=0.05U W=0.195U AS=0.020475P AD=0.01365P PS=0.6U
+ PD=0.335U
M$6 Z \$2 VSS VSS NMOS_VTL L=0.05U W=0.585U AS=0.04095P AD=0.047775P PS=1.005U
+ PD=1.27U
.ENDS CLKBUF_X3

.SUBCKT DFFR_X1 VSS CK QN Q D RN VDD
M$1 VDD \$6 QN VDD PMOS_VTL L=0.05U W=0.63U AS=0.06615P AD=0.0441P PS=1.47U
+ PD=0.77U
M$2 Q \$7 VDD VDD PMOS_VTL L=0.05U W=0.63U AS=0.0441P AD=0.06615P PS=0.77U
+ PD=1.47U
M$3 \$22 \$4 \$6 VDD PMOS_VTL L=0.05U W=0.09U AS=0.014175P AD=0.0063P PS=0.455U
+ PD=0.23U
M$4 VDD \$7 \$22 VDD PMOS_VTL L=0.05U W=0.09U AS=0.0063P AD=0.014175P PS=0.23U
+ PD=0.455U
M$5 VDD \$5 \$18 VDD PMOS_VTL L=0.05U W=0.315U AS=0.03465P AD=0.033075P
+ PS=0.85U PD=0.525U
M$6 \$24 \$5 VDD VDD PMOS_VTL L=0.05U W=0.315U AS=0.033075P AD=0.02205P
+ PS=0.525U PD=0.455U
M$7 \$6 \$2 \$24 VDD PMOS_VTL L=0.05U W=0.315U AS=0.02205P AD=0.014175P
+ PS=0.455U PD=0.455U
M$8 \$7 RN VDD VDD PMOS_VTL L=0.05U W=0.315U AS=0.014175P AD=0.02205P PS=0.455U
+ PD=0.455U
M$9 VDD \$6 \$7 VDD PMOS_VTL L=0.05U W=0.315U AS=0.02205P AD=0.033075P
+ PS=0.455U PD=0.84U
M$10 \$21 \$2 \$5 VDD PMOS_VTL L=0.05U W=0.09U AS=0.01785P AD=0.0063P PS=0.56U
+ PD=0.23U
M$11 VDD \$18 \$21 VDD PMOS_VTL L=0.05U W=0.09U AS=0.0063P AD=0.0063P PS=0.23U
+ PD=0.23U
M$12 \$21 RN VDD VDD PMOS_VTL L=0.05U W=0.09U AS=0.0063P AD=0.01035P PS=0.23U
+ PD=0.41U
M$13 \$23 D VDD VDD PMOS_VTL L=0.05U W=0.42U AS=0.0441P AD=0.0294P PS=1.05U
+ PD=0.56U
M$14 \$5 \$4 \$23 VDD PMOS_VTL L=0.05U W=0.42U AS=0.0294P AD=0.01785P PS=0.56U
+ PD=0.56U
M$15 VDD CK \$2 VDD PMOS_VTL L=0.05U W=0.315U AS=0.033075P AD=0.02205P PS=0.84U
+ PD=0.455U
M$16 \$4 \$2 VDD VDD PMOS_VTL L=0.05U W=0.315U AS=0.02205P AD=0.033075P
+ PS=0.455U PD=0.84U
M$17 \$13 \$4 \$5 VSS NMOS_VTL L=0.05U W=0.09U AS=0.012775P AD=0.0063P
+ PS=0.415U PD=0.23U
M$18 \$12 \$18 \$13 VSS NMOS_VTL L=0.05U W=0.09U AS=0.0063P AD=0.0063P PS=0.23U
+ PD=0.23U
M$19 VSS RN \$12 VSS NMOS_VTL L=0.05U W=0.09U AS=0.0063P AD=0.00945P PS=0.23U
+ PD=0.39U
M$20 \$11 D VSS VSS NMOS_VTL L=0.05U W=0.275U AS=0.028875P AD=0.01925P PS=0.76U
+ PD=0.415U
M$21 \$5 \$2 \$11 VSS NMOS_VTL L=0.05U W=0.275U AS=0.01925P AD=0.012775P
+ PS=0.415U PD=0.415U
M$22 VSS CK \$2 VSS NMOS_VTL L=0.05U W=0.21U AS=0.02205P AD=0.0147P PS=0.63U
+ PD=0.35U
M$23 \$4 \$2 VSS VSS NMOS_VTL L=0.05U W=0.21U AS=0.0147P AD=0.02205P PS=0.35U
+ PD=0.63U
M$24 \$16 \$2 \$6 VSS NMOS_VTL L=0.05U W=0.09U AS=0.0105P AD=0.0063P PS=0.35U
+ PD=0.23U
M$25 VSS \$7 \$16 VSS NMOS_VTL L=0.05U W=0.09U AS=0.0063P AD=0.0105P PS=0.23U
+ PD=0.35U
M$26 VSS \$5 \$18 VSS NMOS_VTL L=0.05U W=0.21U AS=0.02205P AD=0.02205P PS=0.63U
+ PD=0.42U
M$27 \$15 \$5 VSS VSS NMOS_VTL L=0.05U W=0.21U AS=0.02205P AD=0.0147P PS=0.42U
+ PD=0.35U
M$28 \$6 \$4 \$15 VSS NMOS_VTL L=0.05U W=0.21U AS=0.0147P AD=0.0105P PS=0.35U
+ PD=0.35U
M$29 \$14 RN VSS VSS NMOS_VTL L=0.05U W=0.21U AS=0.0105P AD=0.0147P PS=0.35U
+ PD=0.35U
M$30 \$7 \$6 \$14 VSS NMOS_VTL L=0.05U W=0.21U AS=0.0147P AD=0.02205P PS=0.35U
+ PD=0.63U
M$31 VSS \$6 QN VSS NMOS_VTL L=0.05U W=0.415U AS=0.043575P AD=0.02905P PS=1.04U
+ PD=0.555U
M$32 Q \$7 VSS VSS NMOS_VTL L=0.05U W=0.415U AS=0.02905P AD=0.043575P PS=0.555U
+ PD=1.04U
.ENDS DFFR_X1

.SUBCKT HA_X1 A B S VDD VSS CO
M$1 \$12 B VDD VDD PMOS_VTL L=0.05U W=0.315U AS=0.0338625P AD=0.02205P
+ PS=0.775U PD=0.455U
M$2 \$7 A \$12 VDD PMOS_VTL L=0.05U W=0.315U AS=0.02205P AD=0.033075P PS=0.455U
+ PD=0.84U
M$3 S B \$3 VDD PMOS_VTL L=0.05U W=0.63U AS=0.06615P AD=0.0441P PS=1.47U
+ PD=0.77U
M$4 \$3 A S VDD PMOS_VTL L=0.05U W=0.63U AS=0.0441P AD=0.0441P PS=0.77U PD=0.77U
M$5 VDD \$7 \$3 VDD PMOS_VTL L=0.05U W=0.63U AS=0.0441P AD=0.0338625P PS=0.77U
+ PD=0.775U
M$6 \$8 A VDD VDD PMOS_VTL L=0.05U W=0.315U AS=0.033075P AD=0.02205P PS=0.84U
+ PD=0.455U
M$7 \$8 B VDD VDD PMOS_VTL L=0.05U W=0.315U AS=0.033075P AD=0.02205P PS=0.77U
+ PD=0.455U
M$8 CO \$8 VDD VDD PMOS_VTL L=0.05U W=0.63U AS=0.033075P AD=0.06615P PS=0.77U
+ PD=1.47U
M$9 \$14 A \$8 VSS NMOS_VTL L=0.05U W=0.21U AS=0.02205P AD=0.0147P PS=0.63U
+ PD=0.35U
M$10 VSS B \$14 VSS NMOS_VTL L=0.05U W=0.21U AS=0.0147P AD=0.021875P PS=0.35U
+ PD=0.555U
M$11 CO \$8 VSS VSS NMOS_VTL L=0.05U W=0.415U AS=0.021875P AD=0.043575P
+ PS=0.555U PD=1.04U
M$12 \$7 B VSS VSS NMOS_VTL L=0.05U W=0.21U AS=0.0224P AD=0.0147P PS=0.56U
+ PD=0.35U
M$13 VSS A \$7 VSS NMOS_VTL L=0.05U W=0.21U AS=0.0147P AD=0.02205P PS=0.35U
+ PD=0.63U
M$14 \$13 B VSS VSS NMOS_VTL L=0.05U W=0.415U AS=0.043575P AD=0.02905P PS=1.04U
+ PD=0.555U
M$15 S A \$13 VSS NMOS_VTL L=0.05U W=0.415U AS=0.02905P AD=0.02905P PS=0.555U
+ PD=0.555U
M$16 VSS \$7 S VSS NMOS_VTL L=0.05U W=0.415U AS=0.02905P AD=0.0224P PS=0.555U
+ PD=0.56U
.ENDS HA_X1

.SUBCKT FA_X1 VSS B CO S CI A VDD
M$1 \$18 B VDD VDD PMOS_VTL L=0.05U W=0.315U AS=0.033075P AD=0.02205P PS=0.77U
+ PD=0.455U
M$2 \$4 A \$18 VDD PMOS_VTL L=0.05U W=0.315U AS=0.02205P AD=0.02205P PS=0.455U
+ PD=0.455U
M$3 \$16 CI \$4 VDD PMOS_VTL L=0.05U W=0.315U AS=0.02205P AD=0.02265P PS=0.455U
+ PD=0.535U
M$4 VDD A \$16 VDD PMOS_VTL L=0.05U W=0.315U AS=0.02265P AD=0.02205P PS=0.535U
+ PD=0.455U
M$5 \$16 B VDD VDD PMOS_VTL L=0.05U W=0.315U AS=0.02205P AD=0.033075P PS=0.455U
+ PD=0.84U
M$6 VDD \$4 CO VDD PMOS_VTL L=0.05U W=0.63U AS=0.06615P AD=0.033075P PS=1.47U
+ PD=0.77U
M$7 \$17 B VDD VDD PMOS_VTL L=0.05U W=0.315U AS=0.033075P AD=0.02205P PS=0.84U
+ PD=0.455U
M$8 VDD CI \$17 VDD PMOS_VTL L=0.05U W=0.315U AS=0.02205P AD=0.02205P PS=0.455U
+ PD=0.455U
M$9 \$17 A VDD VDD PMOS_VTL L=0.05U W=0.315U AS=0.02205P AD=0.02205P PS=0.455U
+ PD=0.455U
M$10 \$7 \$4 \$17 VDD PMOS_VTL L=0.05U W=0.315U AS=0.02205P AD=0.023625P
+ PS=0.455U PD=0.465U
M$11 \$19 CI \$7 VDD PMOS_VTL L=0.05U W=0.315U AS=0.023625P AD=0.02205P
+ PS=0.465U PD=0.455U
M$12 \$20 B \$19 VDD PMOS_VTL L=0.05U W=0.315U AS=0.02205P AD=0.02205P
+ PS=0.455U PD=0.455U
M$13 \$20 A VDD VDD PMOS_VTL L=0.05U W=0.315U AS=0.033075P AD=0.02205P PS=0.77U
+ PD=0.455U
M$14 S \$7 VDD VDD PMOS_VTL L=0.05U W=0.63U AS=0.033075P AD=0.06615P PS=0.77U
+ PD=1.47U
M$15 \$14 B VSS VSS NMOS_VTL L=0.05U W=0.21U AS=0.021875P AD=0.0147P PS=0.555U
+ PD=0.35U
M$16 \$4 A \$14 VSS NMOS_VTL L=0.05U W=0.21U AS=0.0147P AD=0.0147P PS=0.35U
+ PD=0.35U
M$17 \$5 CI \$4 VSS NMOS_VTL L=0.05U W=0.21U AS=0.0147P AD=0.015225P PS=0.35U
+ PD=0.355U
M$18 VSS A \$5 VSS NMOS_VTL L=0.05U W=0.21U AS=0.015225P AD=0.0147P PS=0.355U
+ PD=0.35U
M$19 \$5 B VSS VSS NMOS_VTL L=0.05U W=0.21U AS=0.0147P AD=0.02205P PS=0.35U
+ PD=0.63U
M$20 VSS \$4 CO VSS NMOS_VTL L=0.05U W=0.415U AS=0.043575P AD=0.021875P
+ PS=1.04U PD=0.555U
M$21 \$6 B VSS VSS NMOS_VTL L=0.05U W=0.21U AS=0.02205P AD=0.0147P PS=0.63U
+ PD=0.35U
M$22 VSS CI \$6 VSS NMOS_VTL L=0.05U W=0.21U AS=0.0147P AD=0.0147P PS=0.35U
+ PD=0.35U
M$23 \$6 A VSS VSS NMOS_VTL L=0.05U W=0.21U AS=0.0147P AD=0.0147P PS=0.35U
+ PD=0.35U
M$24 \$7 \$4 \$6 VSS NMOS_VTL L=0.05U W=0.21U AS=0.0147P AD=0.01575P PS=0.35U
+ PD=0.36U
M$25 \$9 CI \$7 VSS NMOS_VTL L=0.05U W=0.21U AS=0.01575P AD=0.0147P PS=0.36U
+ PD=0.35U
M$26 \$10 B \$9 VSS NMOS_VTL L=0.05U W=0.21U AS=0.0147P AD=0.0147P PS=0.35U
+ PD=0.35U
M$27 VSS A \$10 VSS NMOS_VTL L=0.05U W=0.21U AS=0.0147P AD=0.021875P PS=0.35U
+ PD=0.555U
M$28 S \$7 VSS VSS NMOS_VTL L=0.05U W=0.415U AS=0.021875P AD=0.043575P
+ PS=0.555U PD=1.04U
.ENDS FA_X1

.SUBCKT XOR2_X1 A B VSS VDD Z
M$1 \$10 A \$2 VDD PMOS_VTL L=0.05U W=0.315U AS=0.033075P AD=0.02205P PS=0.84U
+ PD=0.455U
M$2 \$10 B VDD VDD PMOS_VTL L=0.05U W=0.315U AS=0.0338625P AD=0.02205P
+ PS=0.775U PD=0.455U
M$3 \$7 \$2 VDD VDD PMOS_VTL L=0.05U W=0.63U AS=0.0338625P AD=0.0441P PS=0.775U
+ PD=0.77U
M$4 Z A \$7 VDD PMOS_VTL L=0.05U W=0.63U AS=0.0441P AD=0.0441P PS=0.77U PD=0.77U
M$5 \$7 B Z VDD PMOS_VTL L=0.05U W=0.63U AS=0.0441P AD=0.06615P PS=0.77U
+ PD=1.47U
M$6 \$2 A VSS VSS NMOS_VTL L=0.05U W=0.21U AS=0.02205P AD=0.0147P PS=0.63U
+ PD=0.35U
M$7 VSS B \$2 VSS NMOS_VTL L=0.05U W=0.21U AS=0.0147P AD=0.0224P PS=0.35U
+ PD=0.56U
M$8 Z \$2 VSS VSS NMOS_VTL L=0.05U W=0.415U AS=0.0224P AD=0.02905P PS=0.56U
+ PD=0.555U
M$9 \$11 A Z VSS NMOS_VTL L=0.05U W=0.415U AS=0.02905P AD=0.02905P PS=0.555U
+ PD=0.555U
M$10 VSS B \$11 VSS NMOS_VTL L=0.05U W=0.415U AS=0.02905P AD=0.043575P
+ PS=0.555U PD=1.04U
.ENDS XOR2_X1

.SUBCKT AOI21_X1 A B2 B1 VSS ZN VDD
M$1 ZN B2 \$5 VDD PMOS_VTL L=0.05U W=0.63U AS=0.06615P AD=0.0441P PS=1.47U
+ PD=0.77U
M$2 \$5 B1 ZN VDD PMOS_VTL L=0.05U W=0.63U AS=0.0441P AD=0.0441P PS=0.77U
+ PD=0.77U
M$3 VDD A \$5 VDD PMOS_VTL L=0.05U W=0.63U AS=0.0441P AD=0.06615P PS=0.77U
+ PD=1.47U
M$4 \$10 B2 VSS VSS NMOS_VTL L=0.05U W=0.415U AS=0.043575P AD=0.02905P PS=1.04U
+ PD=0.555U
M$5 ZN B1 \$10 VSS NMOS_VTL L=0.05U W=0.415U AS=0.02905P AD=0.02905P PS=0.555U
+ PD=0.555U
M$6 VSS A ZN VSS NMOS_VTL L=0.05U W=0.415U AS=0.02905P AD=0.043575P PS=0.555U
+ PD=1.04U
.ENDS AOI21_X1

.SUBCKT NOR3_X1 A3 A2 A1 VSS VDD ZN
M$1 \$10 A3 VDD VDD PMOS_VTL L=0.05U W=0.63U AS=0.06615P AD=0.0441P PS=1.47U
+ PD=0.77U
M$2 \$9 A2 \$10 VDD PMOS_VTL L=0.05U W=0.63U AS=0.0441P AD=0.0441P PS=0.77U
+ PD=0.77U
M$3 ZN A1 \$9 VDD PMOS_VTL L=0.05U W=0.63U AS=0.0441P AD=0.06615P PS=0.77U
+ PD=1.47U
M$4 ZN A3 VSS VSS NMOS_VTL L=0.05U W=0.415U AS=0.043575P AD=0.02905P PS=1.04U
+ PD=0.555U
M$5 VSS A2 ZN VSS NMOS_VTL L=0.05U W=0.415U AS=0.02905P AD=0.02905P PS=0.555U
+ PD=0.555U
M$6 ZN A1 VSS VSS NMOS_VTL L=0.05U W=0.415U AS=0.02905P AD=0.043575P PS=0.555U
+ PD=1.04U
.ENDS NOR3_X1

.SUBCKT AND2_X1 A1 A2 VDD VSS ZN
M$1 \$3 A1 VDD VDD PMOS_VTL L=0.05U W=0.315U AS=0.033075P AD=0.02205P PS=0.84U
+ PD=0.455U
M$2 \$3 A2 VDD VDD PMOS_VTL L=0.05U W=0.315U AS=0.033075P AD=0.02205P PS=0.77U
+ PD=0.455U
M$3 ZN \$3 VDD VDD PMOS_VTL L=0.05U W=0.63U AS=0.033075P AD=0.06615P PS=0.77U
+ PD=1.47U
M$4 \$9 A1 \$3 VSS NMOS_VTL L=0.05U W=0.21U AS=0.02205P AD=0.0147P PS=0.63U
+ PD=0.35U
M$5 VSS A2 \$9 VSS NMOS_VTL L=0.05U W=0.21U AS=0.0147P AD=0.021875P PS=0.35U
+ PD=0.555U
M$6 ZN \$3 VSS VSS NMOS_VTL L=0.05U W=0.415U AS=0.021875P AD=0.043575P
+ PS=0.555U PD=1.04U
.ENDS AND2_X1

.SUBCKT XNOR2_X1 A B VDD VSS ZN
M$1 \$3 A VDD VDD PMOS_VTL L=0.05U W=0.315U AS=0.033075P AD=0.02205P PS=0.84U
+ PD=0.455U
M$2 \$3 B VDD VDD PMOS_VTL L=0.05U W=0.315U AS=0.0338625P AD=0.02205P PS=0.775U
+ PD=0.455U
M$3 ZN \$3 VDD VDD PMOS_VTL L=0.05U W=0.63U AS=0.0338625P AD=0.0441P PS=0.775U
+ PD=0.77U
M$4 \$10 A ZN VDD PMOS_VTL L=0.05U W=0.63U AS=0.0441P AD=0.0441P PS=0.77U
+ PD=0.77U
M$5 VDD B \$10 VDD PMOS_VTL L=0.05U W=0.63U AS=0.0441P AD=0.06615P PS=0.77U
+ PD=1.47U
M$6 \$11 A \$3 VSS NMOS_VTL L=0.05U W=0.21U AS=0.02205P AD=0.0147P PS=0.63U
+ PD=0.35U
M$7 VSS B \$11 VSS NMOS_VTL L=0.05U W=0.21U AS=0.0147P AD=0.0224P PS=0.35U
+ PD=0.56U
M$8 \$6 \$3 VSS VSS NMOS_VTL L=0.05U W=0.415U AS=0.0224P AD=0.02905P PS=0.56U
+ PD=0.555U
M$9 ZN A \$6 VSS NMOS_VTL L=0.05U W=0.415U AS=0.02905P AD=0.02905P PS=0.555U
+ PD=0.555U
M$10 \$6 B ZN VSS NMOS_VTL L=0.05U W=0.415U AS=0.02905P AD=0.043575P PS=0.555U
+ PD=1.04U
.ENDS XNOR2_X1

.SUBCKT NAND3_X1 A3 A2 A1 VSS VDD ZN
M$1 ZN A3 VDD VDD PMOS_VTL L=0.05U W=0.63U AS=0.06615P AD=0.0441P PS=1.47U
+ PD=0.77U
M$2 VDD A2 ZN VDD PMOS_VTL L=0.05U W=0.63U AS=0.0441P AD=0.0441P PS=0.77U
+ PD=0.77U
M$3 ZN A1 VDD VDD PMOS_VTL L=0.05U W=0.63U AS=0.0441P AD=0.06615P PS=0.77U
+ PD=1.47U
M$4 \$10 A3 VSS VSS NMOS_VTL L=0.05U W=0.415U AS=0.043575P AD=0.02905P PS=1.04U
+ PD=0.555U
M$5 \$9 A2 \$10 VSS NMOS_VTL L=0.05U W=0.415U AS=0.02905P AD=0.02905P PS=0.555U
+ PD=0.555U
M$6 ZN A1 \$9 VSS NMOS_VTL L=0.05U W=0.415U AS=0.02905P AD=0.043575P PS=0.555U
+ PD=1.04U
.ENDS NAND3_X1

.SUBCKT NAND4_X1 A4 A3 A2 A1 VSS VDD ZN
M$1 ZN A4 VDD VDD PMOS_VTL L=0.05U W=0.63U AS=0.06615P AD=0.0441P PS=1.47U
+ PD=0.77U
M$2 VDD A3 ZN VDD PMOS_VTL L=0.05U W=0.63U AS=0.0441P AD=0.0441P PS=0.77U
+ PD=0.77U
M$3 ZN A2 VDD VDD PMOS_VTL L=0.05U W=0.63U AS=0.0441P AD=0.0441P PS=0.77U
+ PD=0.77U
M$4 VDD A1 ZN VDD PMOS_VTL L=0.05U W=0.63U AS=0.0441P AD=0.06615P PS=0.77U
+ PD=1.47U
M$5 \$12 A4 VSS VSS NMOS_VTL L=0.05U W=0.415U AS=0.043575P AD=0.02905P PS=1.04U
+ PD=0.555U
M$6 \$11 A3 \$12 VSS NMOS_VTL L=0.05U W=0.415U AS=0.02905P AD=0.02905P
+ PS=0.555U PD=0.555U
M$7 \$10 A2 \$11 VSS NMOS_VTL L=0.05U W=0.415U AS=0.02905P AD=0.02905P
+ PS=0.555U PD=0.555U
M$8 ZN A1 \$10 VSS NMOS_VTL L=0.05U W=0.415U AS=0.02905P AD=0.043575P PS=0.555U
+ PD=1.04U
.ENDS NAND4_X1

.SUBCKT OAI21_X1 B2 B1 A VDD ZN VSS
M$1 \$10 B2 VDD VDD PMOS_VTL L=0.05U W=0.63U AS=0.06615P AD=0.0441P PS=1.47U
+ PD=0.77U
M$2 ZN B1 \$10 VDD PMOS_VTL L=0.05U W=0.63U AS=0.0441P AD=0.0441P PS=0.77U
+ PD=0.77U
M$3 VDD A ZN VDD PMOS_VTL L=0.05U W=0.63U AS=0.0441P AD=0.06615P PS=0.77U
+ PD=1.47U
M$4 ZN B2 \$4 VSS NMOS_VTL L=0.05U W=0.415U AS=0.043575P AD=0.02905P PS=1.04U
+ PD=0.555U
M$5 \$4 B1 ZN VSS NMOS_VTL L=0.05U W=0.415U AS=0.02905P AD=0.02905P PS=0.555U
+ PD=0.555U
M$6 VSS A \$4 VSS NMOS_VTL L=0.05U W=0.415U AS=0.02905P AD=0.043575P PS=0.555U
+ PD=1.04U
.ENDS OAI21_X1

.SUBCKT OR2_X1 A1 A2 VSS VDD ZN
M$1 \$9 A1 \$4 VDD PMOS_VTL L=0.05U W=0.315U AS=0.033075P AD=0.02205P PS=0.84U
+ PD=0.455U
M$2 \$9 A2 VDD VDD PMOS_VTL L=0.05U W=0.315U AS=0.033075P AD=0.02205P PS=0.77U
+ PD=0.455U
M$3 ZN \$4 VDD VDD PMOS_VTL L=0.05U W=0.63U AS=0.033075P AD=0.06615P PS=0.77U
+ PD=1.47U
M$4 \$4 A1 VSS VSS NMOS_VTL L=0.05U W=0.21U AS=0.02205P AD=0.0147P PS=0.63U
+ PD=0.35U
M$5 VSS A2 \$4 VSS NMOS_VTL L=0.05U W=0.21U AS=0.0147P AD=0.021875P PS=0.35U
+ PD=0.555U
M$6 ZN \$4 VSS VSS NMOS_VTL L=0.05U W=0.415U AS=0.021875P AD=0.043575P
+ PS=0.555U PD=1.04U
.ENDS OR2_X1

.SUBCKT NOR2_X1 A2 A1 VSS VDD ZN
M$1 \$8 A2 VDD VDD PMOS_VTL L=0.05U W=0.63U AS=0.06615P AD=0.0441P PS=1.47U
+ PD=0.77U
M$2 ZN A1 \$8 VDD PMOS_VTL L=0.05U W=0.63U AS=0.0441P AD=0.06615P PS=0.77U
+ PD=1.47U
M$3 ZN A2 VSS VSS NMOS_VTL L=0.05U W=0.415U AS=0.043575P AD=0.02905P PS=1.04U
+ PD=0.555U
M$4 VSS A1 ZN VSS NMOS_VTL L=0.05U W=0.415U AS=0.02905P AD=0.043575P PS=0.555U
+ PD=1.04U
.ENDS NOR2_X1

.SUBCKT INV_X1 A VSS VDD ZN
M$1 ZN A VDD VDD PMOS_VTL L=0.05U W=0.63U AS=0.06615P AD=0.06615P PS=1.47U
+ PD=1.47U
M$2 ZN A VSS VSS NMOS_VTL L=0.05U W=0.415U AS=0.043575P AD=0.043575P PS=1.04U
+ PD=1.04U
.ENDS INV_X1

.SUBCKT NAND2_X1 A2 A1 VSS VDD ZN
M$1 ZN A2 VDD VDD PMOS_VTL L=0.05U W=0.63U AS=0.06615P AD=0.0441P PS=1.47U
+ PD=0.77U
M$2 VDD A1 ZN VDD PMOS_VTL L=0.05U W=0.63U AS=0.0441P AD=0.06615P PS=0.77U
+ PD=1.47U
M$3 \$8 A2 VSS VSS NMOS_VTL L=0.05U W=0.415U AS=0.043575P AD=0.02905P PS=1.04U
+ PD=0.555U
M$4 ZN A1 \$8 VSS NMOS_VTL L=0.05U W=0.415U AS=0.02905P AD=0.043575P PS=0.555U
+ PD=1.04U
.ENDS NAND2_X1
