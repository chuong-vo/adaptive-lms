* Extracted by KLayout on : 28/03/2026 17:45

.SUBCKT tf_lms_sv err[7] err[6] err[5] err[4] err[3] err[1] err[0] adapt_en VSS
+ VDD dxin[0] dxin[1] dxin[3] dxin[4] dxin[2] dxin[5] dxin[6] dxin[7] clock
+ yout[0] yout[2] yout[6] yout[1] yout[5] yout[7] yout[3] yout[4] err[2] xin[6]
+ xin[1] xin[4] xin[7] xin[0] xin[5] xin[2] reset xin[3]
X$2 \$19 VSS VDD err[7] BUF_X1
X$8 \$32 VSS VDD err[6] BUF_X1
X$14 \$66 VSS VDD err[5] BUF_X1
X$20 \$111 VSS VDD err[4] BUF_X1
X$27 \$376 VSS VDD err[3] BUF_X1
X$33 \$204 VSS VDD err[1] BUF_X1
X$39 \$10 VSS VDD err[0] BUF_X1
X$44 adapt_en VSS VDD \$28 BUF_X1
X$49 \$6935 \$7689 \$7681 VDD VSS \$7849 HA_X1
X$54 \$7512 VSS VDD \$7676 INV_X1
X$56 \$5181 \$6233 VSS VDD \$7758 NAND2_X1
X$58 \$7758 VSS VDD \$8011 INV_X1
X$63 \$5579 \$5721 VSS VDD \$7760 NAND2_X1
X$64 \$7760 VSS VDD \$8013 INV_X1
X$67 \$7353 VSS VDD \$7850 INV_X1
X$70 \$5579 \$6233 VSS VDD \$7761 NAND2_X1
X$71 \$7761 VSS VDD \$7782 INV_X1
X$74 \$8010 VSS VDD \$8004 INV_X1
X$76 \$7782 \$8004 \$8002 VDD VSS \$8005 HA_X1
X$77 \$8002 VSS VDD \$7996 INV_X1
X$79 \$7673 \$7513 \$7989 VDD VSS \$7851 HA_X1
X$81 \$7676 \$7672 \$7669 VDD VSS \$7991 HA_X1
X$82 \$7579 \$7515 VSS VDD \$8038 NAND2_X1
X$83 \$7234 \$7669 \$7639 VDD VSS \$7852 HA_X1
X$87 \$7991 VSS VDD \$8133 INV_X1
X$90 \$7989 \$7639 \$7516 VDD VSS \$7853 HA_X1
X$92 VSS \$7666 \$7640 \$8228 \$7969 \$7667 VDD FA_X1
X$96 \$7969 \$7640 VDD VSS \$7762 XNOR2_X1
X$97 \$7762 \$7517 VDD VSS \$7855 XNOR2_X1
X$99 VSS \$7518 \$8138 \$7968 \$7969 \$7571 VDD FA_X1
X$101 \$7641 VSS VDD \$7969 INV_X1
X$102 VSS \$7443 \$7857 \$7764 \$7522 \$7641 VDD FA_X1
X$106 \$7237 \$7521 VDD VSS \$7779 XNOR2_X1
X$107 \$1762 VSS VDD \$5707 CLKBUF_X3
X$111 \$7764 VSS VDD \$8079 INV_X1
X$114 \$7562 VSS VDD \$7858 INV_X1
X$116 \$7652 VSS VDD \$7651 INV_X1
X$117 VSS \$7424 \$7955 \$7652 \$7642 \$7655 VDD FA_X1
X$121 \$7524 \$7651 \$7765 VDD VSS \$7934 HA_X1
X$126 VSS \$7105 \$I72893 \$7645 \$7647 \$5920 VDD DFFR_X1
X$129 \$7955 VSS VDD \$7859 INV_X1
X$133 \$7934 \$7765 \$7644 VSS \$7778 VDD AOI21_X1
X$134 \$7934 \$7765 \$7774 VSS \$8042 VDD AOI21_X1
X$137 \$7644 \$7765 VSS VDD \$7773 XOR2_X1
X$139 VSS \$7105 \$I72519 \$7861 \$7773 \$5920 VDD DFFR_X1
X$141 \$7105 VSS VDD CLKBUF_X1
X$145 \$7375 \$7373 \$7374 VSS \$7770 VDD AOI21_X1
X$156 \$7375 VSS VDD \$7864 INV_X1
X$159 \$7375 \$7373 \$7376 VSS \$7867 VDD AOI21_X1
X$173 \$7412 \$7411 \$7480 VDD VSS \$7327 HA_X1
X$176 \$7415 VSS VDD \$7412 INV_X1
X$177 VSS \$7417 \$7415 \$7329 \$7414 \$7328 VDD FA_X1
X$179 VSS \$7199 \$7483 \$7484 \$7198 \$7332 VDD FA_X1
X$182 \$7333 VSS VDD \$7558 INV_X1
X$184 \$7422 VSS VDD \$7488 INV_X1
X$188 \$7203 VSS VDD \$7563 INV_X1
X$191 VSS \$7334 \$7491 \$7432 \$7430 \$7431 VDD FA_X1
X$192 \$7204 VSS VDD \$7334 INV_X1
X$196 \$7404 \$7195 VDD VSS \$7674 XNOR2_X1
X$198 \$7324 VSS VDD \$I74130 INV_X2
X$201 \$7543 \$7326 VDD VSS \$7930 XNOR2_X1
X$203 \$7326 \$7405 \$7197 VDD \$7404 VSS OAI21_X1
X$209 \$7480 VSS VDD \$7545 INV_X1
X$210 \$7545 \$7678 \$7548 VDD \$7543 VSS OAI21_X1
X$211 \$7327 \$7480 \$7549 VSS \$7405 VDD AOI21_X1
X$212 \$7481 VSS VDD \$7549 INV_X1
X$213 \$7327 VSS VDD \$7548 INV_X1
X$216 \$7329 VSS VDD \$7330 INV_X1
X$217 \$7331 \$7330 \$7482 VDD VSS \$7553 HA_X1
X$219 \$7483 VSS VDD \$7331 INV_X1
X$223 \$7484 VSS VDD \$7555 INV_X1
X$224 \$7558 \$7555 \$7485 VDD VSS \$7487 HA_X1
X$228 \$7490 \$7488 \$7560 VDD VSS \$7489 HA_X1
X$230 \$7202 VSS VDD \$7490 INV_X1
X$234 \$7491 VSS VDD \$7627 INV_X1
X$239 \$7432 VSS VDD \$7566 INV_X1
X$241 \$7207 \$7156 \$7568 VDD VSS \$7437 HA_X1
X$242 VSS \$7437 \$7434 \$7711 \$7435 \$7206 VDD FA_X1
X$248 VSS \$7218 \$8229 \$7462 \$7461 \$7459 VDD FA_X1
X$252 VSS \$7444 \$7628 \$7835 \$7568 \$7492 VDD FA_X1
X$253 \$7493 VSS VDD \$7492 INV_X1
X$257 \$7496 \$7495 \$7494 VDD VSS \$7444 HA_X1
X$258 \$7209 VSS VDD \$7496 INV_X1
X$260 \$7168 VSS VDD \$7629 INV_X1
X$264 \$6175 \$5437 VSS VDD \$7630 NAND2_X1
X$265 \$6175 \$5905 VSS VDD \$7498 NAND2_X1
X$269 \$5861 \$5437 VSS VDD \$7499 NAND2_X1
X$272 \$5861 \$5905 VSS VDD \$7337 NAND2_X1
X$273 \$7337 VSS VDD \$7583 INV_X1
X$274 \$5437 \$5181 VSS VDD \$7338 NAND2_X1
X$275 \$7338 VSS VDD \$7635 INV_X1
X$280 VSS \$7503 \$7502 \$7505 \$7339 \$7589 VDD FA_X1
X$281 \$7462 VSS VDD \$7339 INV_X1
X$283 \$6175 \$6180 VSS VDD \$7713 NAND2_X1
X$287 \$5579 \$6732 VSS VDD \$7601 NAND2_X1
X$290 \$5181 \$6180 VSS VDD \$7346 NAND2_X1
X$291 \$7346 VSS VDD \$7472 INV_X1
X$294 \$6175 \$6732 VSS VDD \$7592 NAND2_X1
X$295 \$5861 \$6732 VSS VDD \$7508 NAND2_X1
X$299 \$5727 \$6562 VSS VDD \$7342 NAND2_X1
X$300 \$7342 VSS VDD \$7509 INV_X1
X$302 \$7601 VSS VDD \$7603 INV_X1
X$303 VSS \$7603 \$7701 \$7607 \$7509 \$7472 VDD FA_X1
X$304 \$7347 VSS VDD \$7470 INV_X1
X$305 \$5437 \$5371 VSS VDD \$7347 NAND2_X1
X$306 \$5905 \$4940 VSS VDD \$7349 NAND2_X1
X$307 \$7349 VSS VDD \$7469 INV_X1
X$309 \$7469 \$7470 \$7689 VDD VSS \$7350 HA_X1
X$315 VSS \$7350 \$7699 \$8269 \$7608 \$7607 VDD FA_X1
X$317 \$5727 \$6180 VSS VDD \$7355 NAND2_X1
X$318 VSS \$7228 \$7351 \$8241 \$7352 \$7354 VDD FA_X1
X$321 \$6180 \$4940 VSS VDD \$7588 NAND2_X1
X$323 \$5371 \$6180 \$7452 VDD VSS \$7358 AND3_X1
X$324 \$7359 \$7233 \$7452 VDD VSS \$7360 HA_X1
X$330 \$5905 \$5371 VSS VDD \$7353 NAND2_X1
X$332 \$7355 VSS VDD \$7354 INV_X1
X$336 \$6732 \$5371 VSS VDD \$7595 NAND2_X1
X$337 \$5727 \$5721 VSS VDD \$8010 NAND2_X1
X$341 \$7595 VSS VDD \$7673 INV_X1
X$343 \$6233 \$5727 VSS VDD \$7512 NAND2_X1
X$346 \$7588 VSS VDD \$7513 INV_X1
X$347 \$7585 VSS VDD \$7672 INV_X1
X$350 \$7514 \$7360 VSS VDD \$7515 NAND2_X1
X$351 \$7358 \$7516 \$7514 VDD VSS \$7574 HA_X1
X$352 \$7574 VSS VDD \$7579 INV_X1
X$354 VSS \$7451 \$8233 \$7666 \$7361 \$6734 VDD FA_X1
X$356 VSS \$7450 \$7571 \$7519 \$7361 \$7447 VDD FA_X1
X$360 \$7238 VSS VDD \$7441 INV_X1
X$363 VSS \$7236 \$7667 \$7518 \$7361 \$6941 VDD FA_X1
X$364 \$7237 VSS VDD \$7361 INV_X1
X$367 \$7519 VSS VDD \$7522 INV_X1
X$368 VSS \$6188 \$7521 \$7641 \$6005 \$7442 VDD FA_X1
X$370 VSS \$6188 \$7562 \$7556 \$6005 \$7364 VDD FA_X1
X$371 VSS \$6188 \$7523 \$7428 \$6005 \$7426 VDD FA_X1
X$372 VSS \$7433 \$7365 \$7642 \$7441 \$7439 VDD FA_X1
X$373 \$7428 VSS VDD \$7367 INV_X1
X$376 \$7556 VSS VDD \$7439 INV_X1
X$379 \$7523 VSS VDD \$7655 INV_X1
X$381 VSS \$7097 \$7368 \$7406 \$7416 \$7408 VDD FA_X1
X$383 \$7406 VSS VDD \$7403 INV_X1
X$387 \$7368 VSS VDD \$7524 INV_X1
X$391 \$7239 \$7403 \$7128 VDD VSS \$7402 HA_X1
X$394 \$7128 VSS VDD \$7551 INV_X1
X$395 \$7551 \$7525 \$7370 VDD \$7774 VSS OAI21_X1
X$397 \$7402 VSS VDD \$7370 INV_X1
X$401 \$7525 \$7128 VDD VSS \$7647 XNOR2_X1
X$404 VSS \$7105 \$I72278 \$7769 \$7255 \$5920 VDD DFFR_X1
X$406 \$5707 VSS VDD \$7105 CLKBUF_X3
X$408 \$7372 \$7383 \$7373 VDD VSS \$7375 HA_X1
X$410 \$6298 \$7379 VDD VSS \$7383 AND2_X1
X$420 \$7376 \$7373 VSS VDD \$7533 XOR2_X1
X$422 VSS \$7105 \$I72500 \$7379 \$7533 \$5920 VDD DFFR_X1
X$442 \$7798 \$7827 \$7922 VDD VSS \$7927 HA_X1
X$444 \$8186 \$7922 \$7829 VDD VSS \$8086 HA_X1
X$445 VSS \$8086 \$8026 \$7735 \$8350 \$7927 VDD FA_X1
X$450 VSS \$8027 \$I72870 \$8028 \$7935 \$7479 VDD DFFR_X1
X$455 \$8182 VSS VDD \$8024 INV_X1
X$456 \$8024 \$8184 \$7827 VDD VSS \$8414 HA_X1
X$459 \$8026 \$8108 \$8085 VDD VSS \$8193 HA_X1
X$460 \$8193 \$8085 \$7830 VSS \$8109 VDD AOI21_X1
X$464 \$8196 \$8201 \$8256 VDD VSS \$8197 HA_X1
X$465 \$8197 VSS VDD \$8258 INV_X1
X$469 \$8111 \$8110 VDD VSS \$8112 XNOR2_X1
X$470 VSS \$8027 \$I72325 \$8114 \$8112 \$7479 VDD DFFR_X1
X$473 VSS \$8027 \$I72305 \$8115 \$8204 \$7479 VDD DFFR_X1
X$474 VSS \$8027 \$I72484 \$8117 \$8207 \$7479 VDD DFFR_X1
X$477 \$7794 \$7950 VSS VDD \$8097 NAND2_X1
X$478 \$8097 \$7625 VDD VSS \$8573 XNOR2_X1
X$481 \$8099 \$7742 VDD VSS \$8362 XNOR2_X1
X$483 \$8099 VSS VDD \$7743 INV_X1
X$485 \$7742 \$7952 VSS VDD \$7950 NAND2_X1
X$489 \$7832 \$8095 VSS VDD \$8213 NAND2_X1
X$490 \$7832 VSS VDD \$7833 INV_X1
X$491 \$8030 \$7833 \$7834 VDD \$7952 VSS OAI21_X1
X$492 \$8093 \$7833 \$7834 VDD \$8118 VSS OAI21_X1
X$493 \$7959 \$7835 \$8095 VDD VSS \$7960 HA_X1
X$494 \$7960 VSS VDD \$8093 INV_X1
X$497 \$7966 \$7836 \$8032 VDD VSS \$8120 HA_X1
X$500 \$7838 \$7839 \$8222 VDD VSS \$8224 HA_X1
X$506 \$8030 \$7832 VDD VSS \$8101 XNOR2_X1
X$507 \$8213 VSS VDD \$8214 INV_X1
X$509 \$8118 \$8214 \$8120 VSS \$8099 VDD AOI21_X1
X$510 VSS \$7747 \$8030 \$8218 \$8216 \$8119 VDD FA_X1
X$511 \$7835 VSS VDD \$8216 INV_X1
X$513 \$8120 VSS VDD \$8119 INV_X1
X$518 \$8222 VSS VDD \$8328 INV_X1
X$519 \$8224 \$8222 VDD VSS \$8121 XNOR2_X1
X$522 \$7498 VSS VDD \$7839 INV_X1
X$523 VSS \$7633 \$8223 \$8033 \$7789 \$7839 VDD FA_X1
X$528 \$8223 VSS VDD \$8227 INV_X1
X$532 \$8122 VSS VDD \$8266 INV_X1
X$535 \$8033 VSS VDD \$8267 INV_X1
X$537 VSS \$8229 \$8748 \$8123 \$8230 \$8122 VDD FA_X1
X$539 VSS \$7842 \$8034 \$8122 \$7843 \$7978 VDD FA_X1
X$542 VSS \$7844 \$8336 \$8088 \$7994 \$5860 VDD FA_X1
X$545 \$7846 VSS VDD \$8000 INV_X1
X$546 \$8000 \$7848 \$8084 VDD VSS \$8129 HA_X1
X$547 \$8088 VSS VDD \$8247 INV_X1
X$553 \$8236 VSS VDD \$8125 INV_X1
X$554 \$7844 VSS VDD \$8124 INV_X1
X$557 \$5997 VSS VDD \$I74145 INV_X4
X$558 \$1762 VSS VDD \$5997 CLKBUF_X3
X$560 VSS \$8247 \$8244 \$8329 \$7223 \$8129 VDD FA_X1
X$562 VSS \$8084 \$8130 \$8273 \$7351 \$8243 VDD FA_X1
X$565 \$8011 \$8013 \$8082 VDD VSS \$8243 HA_X1
X$566 \$8241 \$7850 \$8239 VDD VSS \$8131 HA_X1
X$568 VSS \$8082 \$8083 \$8037 \$7149 \$8005 VDD FA_X1
X$577 VSS \$7996 \$8531 \$8134 \$8081 \$8133 VDD FA_X1
X$579 \$7851 VSS VDD \$8081 INV_X1
X$584 \$7968 VSS VDD \$8039 INV_X1
X$585 \$5707 VSS VDD \$I74148 INV_X4
X$590 \$7853 VSS VDD \$8135 INV_X1
X$595 \$8233 \$8136 VDD VSS \$8137 XNOR2_X1
X$597 VSS \$8228 \$8136 \$8139 \$8232 \$8138 VDD FA_X1
X$598 \$7521 VSS VDD \$8232 INV_X1
X$600 \$8139 VSS VDD \$8220 INV_X1
X$602 VSS \$7857 \$8140 \$8211 \$8039 \$7521 VDD FA_X1
X$604 \$7957 VSS VDD \$7954 INV_X1
X$605 VSS \$7365 \$8144 \$7957 \$8079 \$7858 VDD FA_X1
X$609 \$8144 VSS VDD \$8313 INV_X1
X$613 \$7859 \$7954 \$8148 VDD VSS \$8041 HA_X1
X$618 \$8148 VSS VDD \$8206 INV_X1
X$619 \$8206 \$7778 \$8149 VDD \$8291 VSS OAI21_X1
X$620 \$8041 VSS VDD \$8149 INV_X1
X$621 \$8041 \$8148 \$8150 VSS \$8277 VDD AOI21_X1
X$622 \$8042 VSS VDD \$8150 INV_X1
X$623 \$8042 \$8148 VDD VSS \$8043 XNOR2_X1
X$628 \$7910 \$7860 VSS VDD \$8073 NAND2_X1
X$630 \$7645 \$7909 \$7862 VDD VSS \$7910 HA_X1
X$631 \$7910 VSS VDD \$8064 INV_X1
X$632 \$7860 \$7862 \$7902 VSS VDD \$8044 NAND3_X1
X$634 \$7863 \$7862 VSS VDD \$8045 NAND2_X1
X$636 \$7862 VSS VDD \$8046 INV_X1
X$638 \$7863 \$7373 VSS VDD \$8047 NAND2_X1
X$639 \$7864 \$7865 \$7868 VDD \$7902 VSS OAI21_X1
X$640 \$7863 VSS VDD \$7865 INV_X1
X$641 \$7865 \$7867 \$7868 VDD \$8050 VSS OAI21_X1
X$642 \$7872 VSS VDD \$7868 INV_X1
X$643 \$7769 \$8052 \$7863 VDD VSS \$7872 HA_X1
X$651 \$7861 \$8152 \$7860 VDD VSS \$8151 HA_X1
X$653 \$8073 \$8194 \$8044 VSS VDD \$8188 NAND3_X1
X$655 \$8188 \$8153 \$7376 VSS \$8070 VDD AOI21_X1
X$656 \$8381 \$8046 \$8047 VSS VDD \$8153 NOR3_X1
X$657 \$7868 \$8046 \$8064 VDD \$8154 VSS OAI21_X1
X$659 \$8050 \$8046 VDD VSS \$8473 XNOR2_X1
X$661 \$7770 \$7863 VDD VSS \$8055 XNOR2_X1
X$678 \$10959 \$11635 VSS VDD \$11759 NAND2_X1
X$680 \$11759 VSS VDD \$11722 INV_X1
X$683 \$11192 VSS VDD \$I74136 INV_X2
X$686 \$10615 \$11635 VSS VDD \$11884 NAND2_X1
X$689 \$11884 VSS VDD \$11891 INV_X1
X$690 \$11924 \$11891 \$11883 VDD VSS \$11976 HA_X1
X$691 \$10339 VSS VDD \$11192 CLKBUF_X3
X$694 \$9660 \$11635 \$11514 VDD VSS \$11895 HA_X1
X$695 \$11895 VSS VDD \$11762 INV_X1
X$697 \$11514 VSS VDD \$11901 INV_X1
X$698 \$11899 \$11639 \$11903 VDD \$11761 VSS OAI21_X1
X$700 \$11763 VSS VDD \$11903 INV_X1
X$702 \$11643 \$11901 \$11762 VDD \$11763 VSS OAI21_X1
X$705 \$11642 \$11887 \$11643 VDD \$11927 VSS OAI21_X1
X$709 \$11419 \$11297 \$11764 VSS \$11887 VDD AOI21_X1
X$710 \$11764 \$11647 VDD VSS \$12196 XNOR2_X1
X$712 \$11297 VSS VDD \$11647 INV_X1
X$713 \$11589 \$11859 \$11844 VSS \$11639 VDD AOI21_X1
X$714 \$11647 \$11421 \$11851 VSS VDD \$11859 NOR3_X1
X$721 \$11765 \$11649 VDD VSS \$12197 XNOR2_X1
X$723 \$11649 \$11766 VSS VDD \$11851 NAND2_X1
X$727 \$11650 \$11766 \$11767 VSS \$11765 VDD AOI21_X1
X$728 \$11650 VSS VDD \$11423 INV_X1
X$730 \$11650 \$11766 \$11844 VSS \$11674 VDD AOI21_X1
X$734 \$10221 \$12212 \$11766 VDD VSS \$11650 HA_X1
X$739 \$11450 \$11770 VDD VSS \$11835 AND2_X1
X$740 \$11234 \$11835 \$11772 VDD VSS \$11653 HA_X1
X$741 \$11770 \$11530 \$11665 \$11528 VSS VDD \$11823 NOR4_X1
X$745 \$11653 VSS VDD \$11773 INV_X1
X$747 \$11665 \$11450 VSS VDD \$11784 NAND2_X1
X$750 \$11654 VSS VDD \$11785 INV_X1
X$751 VSS \$11785 \$11795 \$11532 \$11784 \$11655 VDD FA_X1
X$768 \$8705 VSS VDD \$11531 CLKBUF_X3
X$769 \$11772 \$11775 VSS VDD \$11774 NAND2_X1
X$772 \$11792 \$11775 VSS VDD \$11776 NAND2_X1
X$773 \$11775 \$11786 \$11654 VSS VDD \$11937 NAND3_X1
X$775 \$11784 VSS VDD \$11782 INV_X1
X$777 \$11656 \$11782 \$11786 VDD VSS \$11792 HA_X1
X$796 \$11802 \$8564 VSS VDD \$11910 NAND2_X1
X$797 \$11996 \$11965 \$11964 VDD VSS \$11997 HA_X1
X$798 \$11910 VSS VDD \$11965 INV_X1
X$801 VSS \$11749 \$12180 \$11975 \$11969 \$11842 VDD FA_X1
X$802 VSS \$11750 \$I72684 \$11913 \$11975 \$10360 VDD DFFR_X1
X$803 VSS \$11750 \$I72791 \$11915 \$11913 \$10360 VDD DFFR_X1
X$804 \$11915 \$11916 \$11978 VDD VSS \$12002 HA_X1
X$806 VSS \$11282 \$I72883 \$11283 \$12756 \$10360 VDD DFFR_X1
X$810 \$11746 \$8319 VSS VDD \$11995 NAND2_X1
X$811 \$11995 VSS VDD \$11996 INV_X1
X$815 \$11842 \$11969 \$12097 VDD VSS \$12098 HA_X1
X$818 \$11750 VSS VDD \$I55791 INV_X1
X$819 \$11376 VSS VDD \$11750 CLKBUF_X3
X$823 \$12000 \$12001 VDD VSS \$11752 XNOR2_X1
X$824 \$12001 \$11978 \$11485 VSS VDD \$12156 NAND3_X1
X$828 \$11983 VSS VDD \$11916 INV_X1
X$832 \$12079 \$12077 \$11918 VSS \$12076 VDD AOI21_X1
X$834 \$11918 \$12077 VDD VSS \$11983 XNOR2_X1
X$839 \$12081 \$12100 \$12077 VDD VSS \$12079 HA_X1
X$841 VSS \$11919 \$12081 \$11629 \$12140 \$11921 VDD FA_X1
X$842 \$11920 \$11981 \$11631 VDD VSS \$11919 HA_X1
X$844 VSS \$12131 \$11921 \$11981 \$11982 \$11976 VDD FA_X1
X$850 \$12084 \$12068 \$11920 VDD VSS \$12135 HA_X1
X$851 \$12003 VSS VDD \$12084 INV_X1
X$853 \$11295 \$10960 VSS VDD \$12003 NAND2_X1
X$857 \$11292 \$11417 VSS VDD \$12004 NAND2_X1
X$858 \$12004 VSS VDD \$12127 INV_X1
X$861 \$10959 \$12006 VSS VDD \$12067 NAND2_X1
X$863 \$12067 VSS VDD \$11924 INV_X1
X$870 \$10746 \$12006 \$12007 VDD VSS \$12011 HA_X1
X$871 \$12007 VSS VDD \$12013 INV_X1
X$873 \$12011 \$12007 \$11973 VSS \$12008 VDD AOI21_X1
X$874 \$12011 VSS VDD \$12040 INV_X1
X$875 \$11901 \$11968 \$11762 VDD \$11973 VSS OAI21_X1
X$881 \$11762 \$12013 \$12040 VDD \$12194 VSS OAI21_X1
X$885 VSS \$1633 \$I72886 \$1433 \$1364 \$1003 VDD DFFR_X1
X$891 \$1224 VSS VDD \$1371 INV_X1
X$892 \$1371 \$1369 \$1326 VDD \$1226 VSS OAI21_X1
X$894 \$1327 VSS VDD \$1326 INV_X1
X$898 \$1381 \$1378 VSS VDD \$1328 NAND2_X1
X$903 VSS \$1005 \$1329 \$1330 \$1389 \$1228 VDD FA_X1
X$905 VSS \$1395 \$1389 \$1281 \$1553 \$1229 VDD FA_X1
X$906 \$1411 \$1230 VSS VDD \$1395 NOR2_X1
X$919 VSS \$1826 \$I72376 \$1542 \$1432 \$1003 VDD DFFR_X1
X$924 VSS \$1633 \$I72330 \$1700 \$1433 \$1003 VDD DFFR_X1
X$929 \$1436 \$1548 \$1435 VSS \$1369 VDD AOI21_X1
X$930 \$1436 \$1224 VSS VDD \$1325 NAND2_X1
X$931 \$1325 \$1326 \$1487 VSS VDD \$1709 NAND3_X1
X$932 \$1491 \$1490 \$1548 VDD VSS \$1436 HA_X1
X$933 \$1492 VSS VDD \$1491 INV_X1
X$936 \$1272 VSS VDD \$1490 INV_X1
X$942 VSS \$1499 \$1492 \$1500 \$1273 \$1498 VDD FA_X1
X$944 \$1503 VSS VDD \$1499 INV_X1
X$945 \$1329 VSS VDD \$1498 INV_X1
X$948 VSS \$1608 \$1503 \$1504 \$1402 \$1330 VDD FA_X1
X$949 \$109 \$215 VSS VDD \$1737 NOR2_X1
X$953 \$1441 VSS VDD \$1231 INV_X1
X$955 \$1232 VSS VDD \$1402 INV_X1
X$958 \$1442 VSS VDD \$1008 INV_X1
X$961 \$376 VSS VDD \$1230 INV_X1
X$964 \$1445 VSS VDD \$43 BUF_X2
X$970 VSS \$1012 \$I72482 \$1447 \$1528 \$1445 VDD DFFR_X1
X$971 \$85 VSS VDD \$1012 CLKBUF_X3
X$972 \$1012 VSS VDD \$I56413 INV_X1
X$976 VSS \$1335 \$934 \$1013 \$1334 \$1420 VDD FA_X1
X$977 VSS \$1421 \$1420 \$1102 \$1422 \$1423 VDD FA_X1
X$978 \$1336 VSS VDD \$1422 INV_X1
X$983 \$1446 \$1518 VDD VSS \$497 XNOR2_X1
X$984 \$1532 VSS VDD \$1554 INV_X1
X$986 VSS \$1335 \$1532 \$1449 \$1334 \$1448 VDD FA_X1
X$987 \$1535 VSS VDD \$1448 INV_X1
X$990 \$1534 VSS VDD \$1421 INV_X1
X$991 VSS \$1336 \$1535 \$1450 \$1540 \$1534 VDD FA_X1
X$993 \$1106 \$467 VSS VDD \$1336 NAND2_X1
X$994 VSS \$1339 \$1080 \$1426 \$1428 \$1320 VDD FA_X1
X$998 \$943 \$1341 \$1239 VDD \$1238 VSS OAI21_X1
X$999 \$1342 VSS VDD \$1341 INV_X1
X$1005 \$1426 VSS VDD \$1625 INV_X1
X$1007 \$1533 VSS VDD \$1339 INV_X1
X$1008 \$831 \$1315 VSS VDD \$1533 NAND2_X1
X$1014 VSS \$1017 \$I72287 \$1529 \$1525 \$175 VDD DFFR_X1
X$1015 \$1659 \$1529 VSS VDD \$1425 NOR2_X1
X$1017 \$1342 \$943 VDD VSS \$1525 XNOR2_X1
X$1021 \$1452 \$1453 VSS VDD \$1343 NOR2_X1
X$1025 \$1453 \$945 \$1454 VDD \$1571 VSS OAI21_X1
X$1027 \$945 \$1345 VDD VSS \$1304 XNOR2_X1
X$1033 \$1345 \$1455 VSS VDD \$1453 NAND2_X1
X$1034 \$1519 VSS VDD \$1454 INV_X1
X$1038 \$385 \$394 \$1300 VDD VSS \$1298 AND3_X1
X$1040 \$1242 VSS VDD \$1347 INV_X1
X$1041 \$1290 \$1298 \$1345 VDD VSS \$1350 HA_X1
X$1044 VSS \$1023 \$I72662 \$1290 \$1288 \$175 VDD DFFR_X1
X$1046 \$1348 \$1456 \$1574 VDD \$1519 VSS OAI21_X1
X$1048 \$1345 \$1114 VSS VDD \$1516 NAND2_X1
X$1049 \$1347 \$1513 \$1348 VDD \$1770 VSS OAI21_X1
X$1050 \$1345 VSS VDD \$1513 INV_X1
X$1051 \$1513 \$1458 \$1348 VDD \$1764 VSS OAI21_X1
X$1052 \$1350 VSS VDD \$1348 INV_X1
X$1053 \$1242 \$1114 \$1045 VSS \$1458 VDD AOI21_X1
X$1055 \$1351 \$1675 VSS VDD \$1288 XOR2_X1
X$1057 \$1243 \$1279 \$1353 VDD \$1351 VSS OAI21_X1
X$1058 \$1353 \$1246 VSS VDD \$1352 NAND2_X1
X$1059 \$1042 \$1243 \$1353 VDD \$1354 VSS OAI21_X1
X$1061 \$1245 VSS VDD \$1243 INV_X1
X$1063 \$1385 VSS VDD \$1353 INV_X1
X$1070 \$1459 \$1354 VSS VDD \$1460 NAND2_X1
X$1071 \$1459 \$1245 \$763 \$1024 VSS VDD \$1461 NAND4_X1
X$1073 \$1386 \$1489 \$1245 VDD VSS \$1385 HA_X1
X$1075 \$1496 VSS VDD \$1386 INV_X1
X$1077 VSS \$1356 \$1496 \$1384 \$1598 \$1462 VDD FA_X1
X$1079 \$1384 VSS VDD \$1248 INV_X1
X$1080 \$1249 VSS VDD \$1356 INV_X1
X$1081 VSS \$1263 \$1249 \$1265 \$1367 \$1250 VDD FA_X1
X$1086 \$1486 VSS VDD \$1462 INV_X1
X$1087 VSS \$1676 \$1486 \$1250 \$1485 \$1464 VDD FA_X1
X$1088 VSS \$1465 \$1485 \$1374 \$1483 \$1484 VDD FA_X1
X$1090 \$1374 \$1376 \$1251 VDD VSS \$1263 HA_X1
X$1091 \$1466 VSS VDD \$1484 INV_X1
X$1092 \$1591 VSS VDD \$1376 INV_X1
X$1093 \$1481 VSS VDD \$1483 INV_X1
X$1094 \$1357 \$1358 VSS VDD \$1366 NAND2_X1
X$1096 VSS \$1366 \$1252 \$1253 \$1373 \$1468 VDD FA_X1
X$1097 \$1359 VSS VDD \$1254 INV_X1
X$1101 \$1358 \$1467 VSS VDD \$1481 NAND2_X1
X$1104 \$1467 \$1475 VSS VDD \$1373 NAND2_X1
X$1107 \$1589 VSS VDD \$1360 INV_X1
X$1110 \$1357 \$1475 VSS VDD \$1255 NAND2_X1
X$1111 \$1476 \$1358 VSS VDD \$1120 NAND2_X1
X$1115 \$1469 VSS VDD \$1256 INV_X1
X$1120 \$1475 \$1476 \$1473 VDD VSS \$949 AND3_X1
X$1122 \$1470 VSS VDD \$1257 INV_X1
X$1131 \$1690 \$1471 \$1473 VDD VSS \$1362 HA_X1
X$1153 VSS \$12345 \$I72885 \$12999 \$13186 \$5607 VDD DFFR_X1
X$1160 \$11316 VSS VDD \$12724 CLKBUF_X3
X$1172 VSS \$12724 \$I72517 \$13244 \$13153 \$5607 VDD DFFR_X1
X$1173 VSS \$12724 \$I72827 \$8254 \$13167 \$5607 VDD DFFR_X1
X$1176 \$13245 \$13168 VDD VSS \$13169 XNOR2_X1
X$1177 \$13169 VSS VDD \$13196 INV_X1
X$1178 \$13193 \$13196 VDD VSS \$13249 XNOR2_X1
X$1181 VSS \$13080 \$13222 \$13199 \$13170 \$13161 VDD FA_X1
X$1183 \$13199 VSS VDD \$13201 INV_X1
X$1185 \$13202 \$13201 \$13171 VDD VSS \$13172 HA_X1
X$1186 \$13172 \$13171 \$13131 VSS \$13203 VDD AOI21_X1
X$1192 \$13291 VSS VDD \$13293 INV_X1
X$1196 \$13222 VSS VDD \$13294 INV_X1
X$1198 \$13294 \$13293 \$13295 VDD VSS \$13297 HA_X1
X$1199 \$13297 VSS VDD \$13252 INV_X1
X$1201 \$13295 VSS VDD \$13223 INV_X1
X$1202 \$13249 \$13261 VDD VSS \$13314 XNOR2_X1
X$1203 \$13223 \$13203 \$13252 VDD \$13261 VSS OAI21_X1
X$1205 \$13203 \$13223 VDD VSS \$13225 XNOR2_X1
X$1207 \$13225 VSS VDD \$13302 INV_X1
X$1209 \$13244 \$13302 \$13303 VDD VSS \$13262 HA_X1
X$1210 \$13173 VSS VDD \$13208 INV_X1
X$1211 \$13131 \$13171 VDD VSS \$13173 XNOR2_X1
X$1212 \$13113 \$13208 \$13227 VDD VSS \$13174 HA_X1
X$1215 \$13303 VSS VDD \$13226 INV_X1
X$1217 \$13262 VSS VDD \$13263 INV_X1
X$1218 \$13226 \$13306 \$13263 VDD \$13245 VSS OAI21_X1
X$1220 \$5607 VSS VDD \$10360 BUF_X2
X$1221 \$13174 \$13227 \$13255 VSS \$13306 VDD AOI21_X1
X$1222 \$13174 VSS VDD \$13211 INV_X1
X$1225 \$13227 VSS VDD \$13212 INV_X1
X$1226 \$13212 \$13216 \$13211 VDD \$13175 VSS OAI21_X1
X$1232 \$11376 VSS VDD \$13133 CLKBUF_X3
X$1237 \$13175 \$13226 VDD VSS \$13318 XNOR2_X1
X$1239 \$13083 VSS VDD \$13255 INV_X1
X$1240 \$13083 \$13227 VDD VSS \$13315 XNOR2_X1
X$1243 VSS \$13228 \$I72525 \$13319 \$13315 \$10360 VDD DFFR_X1
X$1245 VSS \$13133 \$I72565 \$13323 \$13319 \$10360 VDD DFFR_X1
X$1246 \$13133 VSS VDD \$I74124 INV_X2
X$1248 \$13323 \$13326 \$13087 VDD VSS \$13176 HA_X1
X$1249 \$13176 \$13087 \$13135 VSS \$13231 VDD AOI21_X1
X$1253 \$13176 VSS VDD \$13136 INV_X1
X$1257 \$13327 VSS VDD \$13326 INV_X1
X$1261 \$13248 \$13270 VDD VSS \$13327 XNOR2_X1
X$1262 \$13214 \$13137 VSS VDD \$13248 NAND2_X1
X$1266 \$13177 VSS VDD \$13138 INV_X1
X$1268 \$13139 VSS VDD \$13214 INV_X1
X$1271 VSS \$13140 \$13332 \$13177 \$13243 \$13141 VDD FA_X1
X$1274 \$13333 \$13270 \$13248 VSS \$13271 VDD AOI21_X1
X$1276 \$13332 VSS VDD \$13246 INV_X1
X$1277 \$13246 \$13329 \$13270 VDD VSS \$13333 HA_X1
X$1279 VSS \$13162 \$13178 \$13093 \$12988 \$13334 VDD FA_X1
X$1280 \$13178 VSS VDD \$13141 INV_X1
X$1284 \$11292 \$12290 VSS VDD \$13142 NAND2_X1
X$1288 \$13321 VSS VDD \$13156 INV_X1
X$1291 \$10576 \$12870 VSS VDD \$13234 NAND2_X1
X$1296 VSS \$13160 \$13445 \$13243 \$13312 \$13352 VDD FA_X1
X$1299 \$11383 \$12290 VSS VDD \$13233 NAND2_X1
X$1300 \$13233 VSS VDD \$13380 INV_X1
X$1303 VSS \$13240 \$13440 \$13313 \$13234 \$13276 VDD FA_X1
X$1304 \$11383 \$12870 VSS VDD \$13277 NAND2_X1
X$1305 VSS \$13145 \$13279 \$13312 \$13238 \$13313 VDD FA_X1
X$1307 \$12290 \$12607 VSS VDD \$13436 OR2_X1
X$1311 \$13285 VSS VDD \$13238 INV_X1
X$1314 VSS \$13236 \$13462 \$13285 \$13286 \$13149 VDD FA_X1
X$1315 \$10117 \$12006 VSS VDD \$13184 NAND2_X1
X$1317 \$13184 VSS VDD \$13236 INV_X1
X$1318 \$12607 \$12006 VSS VDD \$13281 NOR2_X1
X$1369 VSS \$1916 \$I72863 \$1918 \$1989 \$1914 VDD DFFR_X1
X$1370 VSS \$1633 \$I72864 \$1915 \$1873 \$1914 VDD DFFR_X1
X$1375 \$1830 \$1922 VSS VDD \$1435 NAND2_X1
X$1376 \$1923 \$1921 \$1830 VDD \$1883 VSS OAI21_X1
X$1380 \$2010 VSS VDD \$1890 INV_X1
X$1384 VSS \$2019 \$1892 \$2012 \$1837 \$1893 VDD FA_X1
X$1385 \$1411 \$1094 VSS VDD \$1893 NOR2_X1
X$1386 \$1832 \$1230 VSS VDD \$2019 NOR2_X1
X$1388 \$1833 \$1230 VSS VDD \$1835 NOR2_X1
X$1389 \$1833 \$487 VSS VDD \$1837 NOR2_X1
X$1391 \$1649 \$487 VSS VDD \$2035 NOR2_X1
X$1396 VSS \$1826 \$I72878 \$1866 \$1862 \$1003 VDD DFFR_X1
X$1397 \$1545 VSS VDD \$1826 CLKBUF_X3
X$1407 VSS \$1826 \$I72377 \$2117 \$1866 \$1003 VDD DFFR_X1
X$1409 VSS \$1633 \$I72895 \$1913 \$1980 \$1003 VDD DFFR_X1
X$1413 VSS \$1633 \$I72276 \$2163 \$1913 \$1003 VDD DFFR_X1
X$1416 VSS \$1916 \$I72343 \$1989 \$1915 \$1914 VDD DFFR_X1
X$1417 VSS \$1916 \$I72319 \$1919 \$1918 \$1914 VDD DFFR_X1
X$1418 VSS \$1916 \$I72520 \$2228 \$1919 \$1914 VDD DFFR_X1
X$1422 \$1994 \$1548 VSS VDD \$1920 XOR2_X1
X$1423 \$1921 \$2173 \$1830 VDD \$1994 VSS OAI21_X1
X$1424 \$1713 \$2120 VSS VDD \$1922 NAND2_X1
X$1425 \$1713 VSS VDD \$1921 INV_X1
X$1427 \$1927 VSS VDD \$1923 INV_X1
X$1428 \$1927 \$1925 \$2005 VSS \$2173 VDD AOI21_X1
X$1429 \$1711 VSS VDD \$2005 INV_X1
X$1432 \$2007 \$2179 \$1925 VDD VSS \$1927 HA_X1
X$1435 \$1887 VSS VDD \$2179 INV_X1
X$1438 \$2012 \$2204 \$2124 VDD VSS \$2010 HA_X1
X$1440 \$1644 \$565 \$2125 VDD VSS \$2195 HA_X1
X$1443 \$1411 \$215 VSS VDD \$2326 NOR2_X1
X$1444 \$1093 \$1094 VSS VDD \$2127 NOR2_X1
X$1445 \$1933 \$1230 VSS VDD \$2199 NOR2_X1
X$1446 \$1832 \$215 VSS VDD \$2235 NOR2_X1
X$1449 \$1832 \$1094 VSS VDD \$2128 NOR2_X1
X$1450 \$1933 \$1098 VSS VDD \$2204 NOR2_X1
X$1453 VSS \$1934 \$1833 \$1062 \$2046 \$1445 VDD DFFR_X1
X$1456 \$1933 \$19 VSS VDD \$825 NAND2_X1
X$1462 \$1840 \$2054 \$2239 VSS VDD \$487 NAND3_X1
X$1465 \$27 VSS VDD \$1840 INV_X1
X$1468 \$590 \$2130 VSS VDD \$755 NAND2_X1
X$1470 VSS \$1934 \$I72665 \$2509 \$628 \$1445 VDD DFFR_X1
X$1471 VSS \$1934 \$1832 \$628 \$2076 \$1445 VDD DFFR_X1
X$1474 \$828 \$2130 VSS VDD \$1444 NAND2_X1
X$1477 \$85 VSS VDD \$1934 CLKBUF_X3
X$1479 VSS \$1012 \$I72634 \$2076 \$1904 \$1445 VDD DFFR_X1
X$1484 \$2095 \$467 VSS VDD \$1534 NAND2_X1
X$1488 \$2093 VSS VDD \$1786 INV_X1
X$1489 VSS \$1017 \$I72758 \$1904 \$2095 \$175 VDD DFFR_X1
X$1494 VSS \$2082 \$2136 \$2137 \$2079 \$2215 VDD FA_X1
X$1497 \$2087 VSS VDD \$2082 INV_X1
X$1501 \$1940 VSS VDD \$1939 INV_X1
X$1503 \$501 \$938 VSS VDD \$2138 NAND2_X1
X$1504 VSS \$2094 \$2087 \$2246 \$2091 \$2142 VDD FA_X1
X$1506 \$817 \$1558 VSS VDD \$1944 NAND2_X1
X$1507 \$1944 VSS VDD \$2183 INV_X1
X$1508 \$1652 \$2107 VSS VDD \$2389 NOR2_X1
X$1509 \$2105 VSS VDD \$2392 INV_X1
X$1511 \$831 \$1655 VSS VDD \$2105 NAND2_X1
X$1513 \$2113 VSS VDD \$1783 INV_X1
X$1514 VSS \$1017 \$2113 \$501 \$2109 \$175 VDD DFFR_X1
X$1516 \$2116 \$1558 \$1563 VDD VSS \$1662 HA_X1
X$1521 VSS \$2472 \$I72966 \$1825 \$1524 \$175 VDD DFFR_X1
X$1525 \$1666 VSS VDD \$2107 INV_X1
X$1526 \$2097 \$2107 \$1570 VDD VSS \$1668 HA_X1
X$1531 \$1668 VSS VDD \$1793 INV_X1
X$1532 \$1947 \$1570 VSS VDD \$1886 NAND2_X1
X$1534 \$1947 VSS VDD \$1574 INV_X1
X$1539 VSS \$652 \$I72707 \$2098 \$1882 \$175 VDD DFFR_X1
X$1542 \$1853 VSS VDD \$2090 INV_X1
X$1543 \$2090 \$1674 \$1952 VDD \$1880 VSS OAI21_X1
X$1544 \$1876 \$1853 VSS VDD \$1951 NAND2_X1
X$1545 \$1951 \$1460 \$1952 \$1461 VSS VDD \$1950 NAND4_X1
X$1547 \$2059 \$1875 \$1675 VDD VSS \$1876 HA_X1
X$1549 \$652 VSS VDD \$I74141 INV_X2
X$1550 \$2044 VSS VDD \$2059 INV_X1
X$1555 \$1854 VSS VDD \$2045 INV_X1
X$1556 \$1855 \$1580 VSS VDD \$1854 NAND2_X1
X$1558 \$1855 \$1586 VSS VDD \$1856 NAND2_X1
X$1561 VSS \$2013 \$2044 \$1872 \$2285 \$1869 VDD FA_X1
X$1562 \$2040 VSS VDD \$1869 INV_X1
X$1563 \$1963 VSS VDD \$2013 INV_X1
X$1565 VSS \$1997 \$1963 \$1738 \$1964 \$1857 VDD FA_X1
X$1567 \$1581 \$1357 VSS VDD \$1968 NAND2_X1
X$1568 \$1968 VSS VDD \$1868 INV_X1
X$1569 \$1583 \$1467 VSS VDD \$1969 NAND2_X1
X$1570 \$1969 VSS VDD \$1979 INV_X1
X$1582 \$2098 \$2349 \$1455 VDD VSS \$1947 HA_X1
X$1588 VSS \$652 \$I72440 \$2097 \$2099 \$175 VDD DFFR_X1
X$1589 \$1950 \$2146 VSS VDD \$2099 XOR2_X1
X$1591 \$2071 VSS VDD \$1952 INV_X1
X$1593 \$2147 \$2171 \$1853 VDD VSS \$2071 HA_X1
X$1594 \$553 VSS VDD \$652 CLKBUF_X3
X$1595 \$1680 \$1467 VSS VDD \$2148 NAND2_X1
X$1597 \$1855 \$1357 VSS VDD \$1958 NAND2_X1
X$1598 \$1958 VSS VDD \$2167 INV_X1
X$1600 \$2149 VSS VDD \$2150 INV_X1
X$1601 \$1959 \$1476 VSS VDD \$2149 NAND2_X1
X$1604 \$2164 VSS VDD \$2042 INV_X1
X$1605 \$1959 \$1586 VSS VDD \$2164 NAND2_X1
X$1606 \$2042 \$2045 \$1676 VDD VSS \$2160 HA_X1
X$1608 VSS \$2278 \$2040 \$1857 \$2004 \$2160 VDD FA_X1
X$1609 \$1680 \$1476 VSS VDD \$1967 NAND2_X1
X$1610 \$1967 VSS VDD \$2155 INV_X1
X$1611 VSS \$1868 \$2004 \$2154 \$1979 \$2155 VDD FA_X1
X$1626 VSS \$3232 \$I72861 \$3132 \$3131 \$1003 VDD DFFR_X1
X$1628 VSS \$3232 \$I72887 \$3295 \$3184 \$1003 VDD DFFR_X1
X$1643 VSS \$3231 \$I72858 \$3024 \$3291 \$1003 VDD DFFR_X1
X$1650 VSS \$3232 \$I72310 \$3466 \$3295 \$1003 VDD DFFR_X1
X$1652 VSS \$3668 \$I72293 \$3468 \$3424 \$1003 VDD DFFR_X1
X$1653 \$1762 VSS VDD \$1545 CLKBUF_X3
X$1658 VSS \$2981 \$I72545 \$3236 \$3136 \$2883 VDD DFFR_X1
X$1662 VSS \$2981 \$I72546 \$3238 \$3313 \$2883 VDD DFFR_X1
X$1667 VSS \$2982 \$I72663 \$3490 \$3141 \$1445 VDD DFFR_X1
X$1670 \$2883 VSS VDD \$1445 BUF_X1
X$1671 \$2982 VSS VDD \$I74121 INV_X2
X$1672 \$85 VSS VDD \$2982 CLKBUF_X3
X$1675 VSS \$2982 \$3069 \$I65925 \$3325 \$1445 VDD DFFR_X1
X$1677 VSS \$2982 \$I72487 \$3429 \$19 \$1445 VDD DFFR_X1
X$1684 \$3243 \$3241 \$2407 VDD VSS \$2588 HA_X1
X$1685 \$2588 \$2641 VSS VDD \$3223 NAND2_X1
X$1688 \$3144 \$3223 \$3430 \$3225 VSS VDD \$3339 NAND4_X1
X$1690 \$3339 \$3146 VDD VSS \$3148 XNOR2_X1
X$1692 \$3147 \$3244 VSS VDD \$1755 NAND2_X1
X$1696 VSS \$19 \$27 \$3147 \$3244 VDD AOI21_X4
X$1697 \$3148 VSS VDD \$3245 INV_X1
X$1698 \$3229 \$3347 VSS \$3246 VDD NAND2_X4
X$1700 \$3229 \$3347 \$3148 VSS \$3147 VDD NAND3_X4
X$1703 \$3247 \$2990 VSS \$3347 VDD NAND2_X4
X$1704 \$3248 \$2991 \$3149 VSS \$3229 VDD NAND3_X4
X$1706 \$3249 \$600 VSS VDD \$3149 NAND2_X2
X$1707 \$600 VSS VDD \$3356 INV_X1
X$1712 \$3151 \$3226 \$3250 VDD VSS \$3252 HA_X1
X$1713 \$3152 \$2992 \$3433 VDD VSS \$3255 HA_X1
X$1716 VSS \$2999 \$3153 \$3386 \$1940 \$3257 VDD FA_X1
X$1717 \$3256 VSS VDD \$175 BUF_X2
X$1720 \$3247 VSS VDD \$3248 INV_X1
X$1722 \$3357 \$3356 VSS VDD \$2991 NAND2_X2
X$1723 \$3249 VSS VDD \$3357 INV_X1
X$1726 \$740 \$3973 VSS VDD \$3249 XNOR2_X2
X$1728 \$3370 VSS VDD \$3515 INV_X1
X$1729 \$3252 \$3250 \$3514 VSS \$3251 VDD AOI21_X1
X$1730 \$3251 \$2133 VSS VDD \$3370 XOR2_X1
X$1731 \$3252 \$2133 VSS VDD \$3253 NAND2_X1
X$1733 \$3255 VSS VDD \$3520 INV_X1
X$1737 VSS \$4188 \$3257 \$608 \$4220 \$3256 VDD DFFR_X1
X$1738 VSS \$3386 \$3258 \$3260 \$3391 \$3392 VDD FA_X1
X$1740 VSS \$3155 \$3259 \$3261 \$3395 \$3000 VDD FA_X1
X$1742 \$3156 \$3218 \$3264 VDD VSS \$3265 HA_X1
X$1744 \$3157 VSS VDD \$3266 INV_X1
X$1745 \$3114 \$1315 VSS VDD \$3157 NAND2_X1
X$1747 \$3409 VSS VDD \$3419 INV_X1
X$1749 \$2518 \$1315 VSS VDD \$3269 NAND2_X1
X$1751 \$3114 \$1558 VSS VDD \$3420 NAND2_X1
X$1754 \$2518 \$1558 VSS VDD \$3398 NAND2_X1
X$1757 \$3161 \$3162 \$3272 VDD VSS \$3274 HA_X1
X$1760 \$3738 \$3208 VDD VSS \$3211 XNOR2_X1
X$1761 \$3378 \$3209 VDD VSS \$3208 XNOR2_X1
X$1764 \$3010 VSS VDD \$3373 INV_X1
X$1765 \$3348 \$3010 VDD VSS \$3378 XNOR2_X1
X$1766 \$3448 VSS VDD \$3207 INV_X1
X$1768 VSS \$3364 \$3166 \$3167 \$3366 \$3276 VDD FA_X1
X$1771 VSS \$2767 \$3010 \$3276 \$2531 \$3204 VDD FA_X1
X$1772 \$3506 VSS VDD \$3205 INV_X1
X$1775 VSS \$3278 \$3204 \$3348 \$3085 \$3168 VDD FA_X1
X$1776 \$3169 VSS VDD \$3168 INV_X1
X$1778 \$3014 \$1467 VSS VDD \$3169 NAND2_X1
X$1780 \$3259 VSS VDD \$3391 INV_X1
X$1781 \$3260 VSS VDD \$3545 INV_X1
X$1784 \$2709 VSS VDD \$3441 INV_X1
X$1787 VSS \$3264 \$3262 \$3263 \$3220 \$3404 VDD FA_X1
X$1789 \$3265 VSS VDD \$3392 INV_X1
X$1791 \$3407 \$3266 \$3406 VDD VSS \$3404 HA_X1
X$1792 \$3406 VSS VDD \$3268 INV_X1
X$1793 \$3419 \$3418 \$3642 VDD VSS \$3548 HA_X1
X$1795 \$3401 VSS VDD \$3444 INV_X1
X$1797 \$3269 VSS VDD \$3413 INV_X1
X$1798 \$3420 VSS VDD \$3408 INV_X1
X$1800 \$3413 \$3408 \$3403 VDD VSS \$3401 HA_X1
X$1801 \$3403 VSS VDD \$3270 INV_X1
X$1802 \$3398 VSS VDD \$3537 INV_X1
X$1804 \$3393 VSS VDD \$3273 INV_X1
X$1805 \$3274 VSS VDD \$3271 INV_X1
X$1813 \$3527 \$3381 VDD VSS \$3209 XNOR2_X1
X$1814 VSS \$3629 \$3381 \$3275 \$3373 \$3380 VDD FA_X1
X$1821 \$3276 VSS VDD \$3447 INV_X1
X$1822 \$3512 VSS VDD \$3366 INV_X1
X$1826 \$3279 VSS VDD \$2944 INV_X1
X$1827 \$3280 VSS VDD \$3278 INV_X1
X$1828 VSS \$3324 \$3279 \$3455 \$3201 \$3280 VDD FA_X1
X$1829 \$3014 \$1476 VSS VDD \$3201 NAND2_X1
X$1830 \$3201 VSS VDD \$3085 INV_X1
X$1834 \$1959 \$1467 VSS VDD \$3324 NAND2_X1
X$1835 \$3478 VSS VDD \$3197 INV_X1
X$1842 \$2921 \$1581 VSS VDD \$3286 NAND2_X1
X$1843 \$3286 VSS VDD \$3285 INV_X1
X$1845 \$1358 \$3065 VSS VDD \$3307 NOR2_X1
X$1846 VSS \$3172 \$3193 \$3189 \$3307 \$3190 VDD FA_X1
X$1849 \$1581 \$1578 VSS VDD \$3314 NAND2_X1
X$1852 \$1583 \$1578 VSS VDD \$3301 NAND2_X1
X$1854 \$3301 VSS VDD \$3059 INV_X1
X$1857 \$3305 VSS VDD \$3020 CLKBUF_X3
X$1859 VSS \$3020 \$I72974 \$3037 \$3298 \$2922 VDD DFFR_X1
X$1864 VSS \$3020 \$I72419 \$3298 \$3294 \$2922 VDD DFFR_X1
X$1868 VSS \$3456 \$I72814 \$1358 \$3289 \$2922 VDD DFFR_X1
X$1879 VSS \$3456 \$I72468 \$3289 \$3458 \$2922 VDD DFFR_X1
X$1891 VSS \$12345 \$I72859 \$12809 \$12899 \$5607 VDD DFFR_X1
X$1907 \$11316 VSS VDD \$12345 CLKBUF_X3
X$1910 VSS \$12345 \$I72530 \$13105 \$11323 \$5607 VDD DFFR_X1
X$1915 VSS \$12724 \$I72488 \$13026 \$12819 \$5607 VDD DFFR_X1
X$1917 \$12774 \$12821 VSS VDD \$12905 XOR2_X1
X$1919 \$12775 \$13033 VDD VSS \$12821 XNOR2_X1
X$1920 \$12905 \$12825 VDD VSS \$12907 XNOR2_X1
X$1921 \$12683 \$12734 VDD VSS \$12825 XNOR2_X1
X$1930 \$12684 \$12907 VDD VSS \$12950 XNOR2_X1
X$1934 \$12978 VSS VDD \$13036 INV_X1
X$1936 \$12982 VSS VDD \$13000 INV_X1
X$1938 VSS \$11908 \$12982 \$13041 \$12491 \$12951 VDD FA_X1
X$1942 VSS \$11908 \$12952 \$13111 \$12491 \$12986 VDD FA_X1
X$1944 \$12917 VSS VDD \$12840 INV_X1
X$1945 VSS \$12781 \$12913 \$12917 \$12491 \$11908 VDD FA_X1
X$1952 \$12913 VSS VDD \$12992 INV_X1
X$1954 \$12918 VSS VDD \$13004 INV_X1
X$1962 \$12919 VSS VDD \$12921 INV_X1
X$1964 \$12921 \$12784 VSS VDD \$13050 NAND2_X1
X$1969 VSS \$12753 \$I72728 \$12789 \$12854 \$11529 VDD DFFR_X1
X$1970 VSS \$13133 \$I72630 \$12935 \$12789 \$11529 VDD DFFR_X1
X$1972 VSS \$12184 \$I72709 \$10117 \$12935 \$11529 VDD DFFR_X1
X$1978 VSS \$11583 \$I72261 \$12953 \$11746 \$10360 VDD DFFR_X1
X$1981 \$11376 VSS VDD \$12753 CLKBUF_X3
X$1986 \$13012 \$12790 \$12996 VSS \$12957 VDD AOI21_X1
X$1987 \$13012 \$12790 \$12694 VSS \$12882 VDD AOI21_X1
X$1990 VSS \$12938 \$13013 \$12883 \$13125 \$12993 VDD FA_X1
X$1991 \$12883 VSS VDD \$12793 INV_X1
X$1994 VSS \$12796 \$12958 \$12795 \$12944 \$12607 VDD FA_X1
X$1995 VSS \$12869 \$12938 \$12863 \$12932 \$12884 VDD FA_X1
X$1996 \$12945 VSS VDD \$12885 INV_X1
X$1997 \$10615 \$12870 VSS VDD \$12945 NAND2_X1
X$1998 \$12934 VSS VDD \$12937 INV_X1
X$2002 VSS \$12798 \$12934 \$12855 \$12927 \$12925 VDD FA_X1
X$2006 VSS \$12943 \$12993 \$12884 \$12937 \$12958 VDD FA_X1
X$2007 \$12988 VSS VDD \$12943 INV_X1
X$2011 \$12796 VSS VDD \$12985 INV_X1
X$2012 \$12885 \$12985 \$12988 VDD VSS \$13334 HA_X1
X$2013 VSS \$12887 \$13069 \$12932 \$12924 \$13065 VDD FA_X1
X$2017 \$11383 \$11635 VSS VDD \$12888 NAND2_X1
X$2018 \$12888 VSS VDD \$12927 INV_X1
X$2019 \$12980 VSS VDD \$12925 INV_X1
X$2020 \$10576 \$12290 VSS VDD \$12980 NAND2_X1
X$2023 \$12976 VSS VDD \$12924 INV_X1
X$2024 VSS \$12914 \$12977 \$12976 \$12610 \$13030 VDD FA_X1
X$2025 \$12890 VSS VDD \$12914 INV_X1
X$2026 \$10117 \$11417 VSS VDD \$12890 NAND2_X1
X$2030 \$11929 \$12909 VDD VSS \$12903 XNOR2_X1
X$2031 \$12801 VSS VDD \$12909 INV_X1
X$2032 \$12615 \$12870 \$12801 VDD VSS \$12894 HA_X1
X$2033 \$12894 \$12802 VSS VDD \$12832 NAND2_X1
X$2034 \$12802 VSS VDD \$12904 INV_X1
X$2036 VSS \$12391 \$I72824 \$12806 \$12903 \$11529 VDD DFFR_X1
X$2037 \$12806 \$12714 VSS VDD \$12403 NOR2_X2
X$2055 \$12607 \$11417 VSS VDD \$13029 NOR2_X1
X$2056 \$12964 VSS VDD \$13016 INV_X1
X$2058 \$10117 \$11635 VSS VDD \$12964 NAND2_X1
X$2061 \$12909 \$12838 \$12893 VDD \$12966 VSS OAI21_X1
X$2063 \$12894 VSS VDD \$12893 INV_X1
X$2064 \$12966 \$12904 VDD VSS \$12896 XNOR2_X1
X$2065 VSS \$12391 \$I72362 \$12805 \$12896 \$11529 VDD DFFR_X1
X$2095 VSS \$5961 \$I72840 \$6245 \$6516 \$5607 VDD DFFR_X1
X$2098 \$6403 \$6466 \$6247 VDD VSS \$6603 HA_X1
X$2099 \$6603 VSS VDD \$6404 INV_X1
X$2104 VSS \$5612 \$6527 \$6403 \$1328 \$4645 VDD DFFR_X1
X$2110 VSS \$5506 \$I72803 \$6595 \$6402 \$5607 VDD DFFR_X1
X$2116 VSS \$6515 \$I72252 \$6673 \$6595 \$5607 VDD DFFR_X1
X$2118 \$6515 VSS VDD \$I74127 INV_X2
X$2119 VSS \$6515 \$I72456 \$6516 \$6768 \$5607 VDD DFFR_X1
X$2122 \$6600 \$6518 VDD VSS \$6773 XNOR2_X1
X$2124 \$6517 VSS VDD \$6518 INV_X1
X$2125 \$6519 \$6517 \$6600 VSS \$6968 VDD AOI21_X1
X$2128 \$6519 VSS VDD \$6521 INV_X1
X$2131 \$6523 \$4933 VSS VDD \$6674 NAND2_X1
X$2132 \$6681 VSS VDD \$6523 INV_X1
X$2134 \$6678 \$6523 \$6680 VSS VDD \$6610 NAND3_X1
X$2135 \$6680 \$6681 \$6678 VDD VSS \$6059 AND3_X1
X$2137 \$6610 \$6909 VDD VSS \$6525 XNOR2_X1
X$2138 \$6525 \$6524 VSS VDD \$6526 NAND2_X1
X$2139 \$6526 VSS VDD \$6683 INV_X1
X$2145 \$6338 VSS VDD \$6809 INV_X1
X$2146 VSS \$6407 \$6686 \$6687 \$6406 \$6336 VDD FA_X1
X$2148 VSS \$6913 \$6336 \$5884 \$6690 \$6484 VDD FA_X1
X$2152 VSS \$6411 \$6530 \$6413 \$6414 \$6356 VDD FA_X1
X$2153 \$6414 VSS VDD \$6415 INV_X1
X$2156 \$5398 \$5469 VSS VDD \$6414 NAND2_X1
X$2158 \$5473 \$5469 VSS VDD \$6534 NAND2_X1
X$2162 \$6408 VSS VDD \$6688 INV_X1
X$2166 \$6530 VSS VDD \$6815 INV_X1
X$2170 \$5190 \$5724 VSS VDD \$7021 NAND2_X1
X$2172 \$6626 VSS VDD \$6692 INV_X1
X$2173 \$5473 \$5315 VSS VDD \$6626 NAND2_X1
X$2175 \$6534 VSS VDD \$6500 INV_X1
X$2177 VSS \$6535 \$7025 \$6637 \$6418 \$6500 VDD FA_X1
X$2180 \$6637 VSS VDD \$6505 INV_X1
X$2185 \$6833 \$6835 \$6690 VDD VSS \$6913 HA_X1
X$2186 \$6643 VSS VDD \$6833 INV_X1
X$2187 \$6837 VSS VDD \$6835 INV_X1
X$2189 \$5473 \$303 VSS VDD \$6699 NAND2_X1
X$2191 \$5398 \$303 VSS VDD \$6643 NAND2_X1
X$2192 \$5398 \$6137 VSS VDD \$6837 NAND2_X1
X$2195 \$5473 \$6137 VSS VDD \$6701 NAND2_X1
X$2196 \$5190 \$303 VSS VDD \$6539 NAND2_X1
X$2197 \$6539 VSS VDD \$6704 INV_X1
X$2199 \$6424 VSS VDD \$6423 INV_X1
X$2200 VSS \$6423 \$7031 \$6706 \$6421 \$6513 VDD FA_X1
X$2202 \$5476 \$5315 VSS VDD \$6424 NAND2_X1
X$2203 \$4847 \$5724 VSS VDD \$6541 NAND2_X1
X$2204 \$6541 VSS VDD \$6656 INV_X1
X$2205 VSS \$6661 \$6653 \$6543 \$6656 \$6429 VDD FA_X1
X$2206 \$6431 VSS VDD \$6661 INV_X1
X$2207 \$4632 \$5315 VSS VDD \$6431 NAND2_X1
X$2212 \$4752 \$303 VSS VDD \$6707 NAND2_X1
X$2213 \$6709 VSS VDD \$7041 INV_X1
X$2215 \$5190 \$6137 VSS VDD \$6709 NAND2_X1
X$2218 \$5283 \$5724 VSS VDD \$6545 NAND2_X1
X$2220 \$6545 VSS VDD \$6546 INV_X1
X$2224 \$4752 \$6137 VSS VDD \$6921 NAND2_X1
X$2225 VSS \$6668 \$7042 \$7495 \$6546 \$6863 VDD FA_X1
X$2226 \$6547 VSS VDD \$6668 INV_X1
X$2227 \$4847 \$5315 VSS VDD \$6547 NAND2_X1
X$2230 \$6862 VSS VDD \$6863 INV_X1
X$2231 \$4632 \$5469 VSS VDD \$6862 NAND2_X1
X$2232 \$6665 VSS VDD \$6380 CLKBUF_X3
X$2233 VSS \$6380 \$I72757 \$6498 \$5724 \$5084 VDD DFFR_X1
X$2236 VSS \$6380 \$I72723 \$6645 \$6498 \$5084 VDD DFFR_X1
X$2239 VSS \$5625 \$I72756 \$6562 \$6645 \$5084 VDD DFFR_X1
X$2242 \$5905 \$5727 VSS VDD \$6640 NAND2_X1
X$2245 \$5469 \$4847 VSS VDD \$6713 NAND2_X1
X$2246 \$5315 \$5283 VSS VDD \$6714 NAND2_X1
X$2248 \$6137 \$5476 VSS VDD \$6716 NAND2_X1
X$2250 \$303 \$4632 VSS VDD \$6718 NAND2_X1
X$2252 \$6137 \$4632 VSS VDD \$6559 NAND2_X1
X$2253 \$6559 VSS VDD \$6867 INV_X1
X$2257 \$6720 \$5283 \$6137 VDD VSS \$6722 AND3_X1
X$2258 clock VSS VDD \$1762 CLKBUF_X3
X$2259 \$303 \$4847 VSS VDD \$6886 NAND2_X1
X$2260 VSS \$5625 \$I72337 \$6891 \$5315 \$5084 VDD DFFR_X1
X$2261 VSS \$6563 \$I72332 \$6564 \$6891 \$5084 VDD DFFR_X1
X$2262 VSS \$6563 \$I72575 \$6732 \$6564 \$5084 VDD DFFR_X1
X$2266 VSS \$6631 \$6725 \$6726 \$6898 \$6634 VDD FA_X1
X$2268 \$6640 VSS VDD \$6634 INV_X1
X$2269 \$4940 \$6436 VSS VDD \$6898 NOR2_X1
X$2270 \$6636 VSS VDD \$6631 INV_X1
X$2272 \$5437 \$4754 VSS VDD \$6636 NAND2_X1
X$2281 \$5437 \$4940 VSS VDD \$6629 NAND2_X1
X$2282 \$5371 \$6436 VSS VDD \$6892 NOR2_X1
X$2283 \$5905 \$4754 VSS VDD \$7055 NAND2_X1
X$2284 \$6629 VSS VDD \$6730 INV_X1
X$2286 \$6563 VSS VDD \$I74116 INV_X2
X$2287 \$5997 VSS VDD \$6563 CLKBUF_X3
X$2290 VSS \$6563 \$I72436 \$6860 \$6732 \$5851 VDD DFFR_X1
X$2291 VSS \$5779 \$I72596 \$6277 \$6562 \$5851 VDD DFFR_X1
X$2297 VSS \$6001 \$I72998 \$5320 \$6624 \$5851 VDD DFFR_X1
X$2301 \$4664 \$4822 VSS VDD \$6618 NAND2_X1
X$2302 \$4664 \$5635 \$6618 VDD \$6572 VSS OAI21_X1
X$2303 \$5635 \$4946 VSS VDD \$6573 OR2_X1
X$2304 \$4821 \$5635 VSS VDD \$6574 NOR2_X1
X$2305 \$4946 \$4822 VSS VDD \$6855 NAND2_X1
X$2308 VSS \$6563 \$I72555 \$6859 \$6860 \$5851 VDD DFFR_X1
X$2311 VSS \$6563 \$I72280 \$4392 \$6859 \$5851 VDD DFFR_X1
X$2315 VSS \$6573 \$6734 \$7236 \$6439 \$6618 VDD FA_X1
X$2316 \$6855 VSS VDD \$6849 INV_X1
X$2320 \$4759 \$5635 VSS VDD \$6478 NOR2_X1
X$2325 \$4664 \$4677 VSS VDD \$6737 NAND2_X1
X$2329 \$4664 \$3996 VSS VDD \$6739 NAND2_X1
X$2330 \$4664 \$4392 VSS VDD \$6740 NAND2_X1
X$2332 \$4946 \$4677 VSS VDD \$6834 NAND2_X1
X$2334 \$6578 VSS VDD \$6820 INV_X1
X$2345 VSS \$5961 \$I72836 \$5962 \$6245 \$4645 VDD DFFR_X1
X$2347 \$6205 \$6247 VDD VSS \$6320 XNOR2_X1
X$2348 \$4488 VSS VDD \$5961 CLKBUF_X3
X$2349 \$6159 VSS VDD \$6248 INV_X1
X$2358 dxin[7] VSS VDD \$6402 BUF_X1
X$2364 \$6247 VSS VDD \$6309 INV_X1
X$2365 \$6309 \$6312 \$6404 VDD \$6600 VSS OAI21_X1
X$2366 \$6517 \$6247 VSS VDD \$6043 NAND2_X1
X$2368 \$6404 \$6518 \$6521 \$6043 \$6248 VDD VSS \$6317 OAI221_X1
X$2370 VSS \$5961 \$I72653 \$6217 \$6320 \$4645 VDD DFFR_X1
X$2372 \$6217 \$4933 VSS VDD \$6325 NAND2_X1
X$2378 \$6325 VSS VDD \$6466 INV_X1
X$2381 VSS \$5946 \$6164 \$6338 \$6333 \$6165 VDD FA_X1
X$2382 VSS \$5612 \$I72788 \$5750 \$6163 \$4645 VDD DFFR_X1
X$2387 \$6065 \$6476 VDD VSS \$7194 XNOR2_X1
X$2388 \$6337 \$6475 VDD VSS \$6476 XNOR2_X1
X$2391 \$6336 VSS VDD \$6333 INV_X1
X$2392 \$6229 \$6336 VDD VSS \$6337 XNOR2_X1
X$2393 \$6344 VSS VDD \$6406 INV_X1
X$2395 VSS \$6347 \$6407 \$6408 \$6339 \$5884 VDD FA_X1
X$2398 VSS \$6254 \$6484 \$6229 \$6415 \$6409 VDD FA_X1
X$2399 \$6231 VSS VDD \$7017 INV_X1
X$2406 \$6356 VSS VDD \$6254 INV_X1
X$2408 \$6410 VSS VDD \$6409 INV_X1
X$2409 \$5398 \$5724 VSS VDD \$6410 NAND2_X1
X$2410 \$5473 \$5724 VSS VDD \$6411 NAND2_X1
X$2411 VSS \$6256 \$6489 \$6416 \$6355 \$6413 VDD FA_X1
X$2412 \$5398 \$5315 VSS VDD \$6356 NAND2_X1
X$2415 \$4752 \$5724 VSS VDD \$6260 NAND2_X1
X$2416 \$6260 VSS VDD \$6418 INV_X1
X$2419 \$6419 VSS VDD \$6535 INV_X1
X$2420 \$5190 \$5315 VSS VDD \$6419 NAND2_X1
X$2423 VSS \$6368 \$6501 \$7070 \$6167 \$6505 VDD FA_X1
X$2424 \$6168 VSS VDD \$6368 INV_X1
X$2427 VSS \$6375 \$6262 \$6263 \$6372 \$5859 VDD FA_X1
X$2433 \$6262 VSS VDD \$6420 INV_X1
X$2437 \$4632 \$5724 VSS VDD \$6265 NAND2_X1
X$2438 \$6265 VSS VDD \$6421 INV_X1
X$2439 \$4752 \$5469 VSS VDD \$6267 NAND2_X1
X$2440 \$6169 \$6241 \$6266 VDD VSS \$6375 HA_X1
X$2445 \$6267 VSS VDD \$6513 INV_X1
X$2448 \$5476 \$5469 VSS VDD \$6268 NAND2_X1
X$2449 \$6268 VSS VDD \$6429 INV_X1
X$2450 \$6170 VSS VDD \$6430 INV_X1
X$2452 VSS \$6380 \$I72961 \$6172 \$6244 \$5084 VDD DFFR_X1
X$2454 VSS \$6380 \$I72937 \$6175 \$6172 \$5084 VDD DFFR_X1
X$2456 VSS \$5596 \$I72732 \$6389 \$5469 \$5084 VDD DFFR_X1
X$2461 \$6380 VSS VDD \$I74129 INV_X2
X$2465 VSS \$5596 \$I72957 \$6392 \$6389 \$5084 VDD DFFR_X1
X$2470 \$5625 VSS VDD CLKBUF_X1
X$2472 VSS \$5625 \$I72929 \$6180 \$6392 \$5084 VDD DFFR_X1
X$2473 \$5997 VSS VDD \$5625 CLKBUF_X3
X$2476 VSS \$5625 \$I72738 \$6399 \$6175 \$5084 VDD DFFR_X1
X$2479 VSS \$5775 \$I72623 \$6274 \$6400 \$5851 VDD DFFR_X1
X$2480 VSS \$5775 \$I72686 \$6400 \$6399 \$5851 VDD DFFR_X1
X$2481 VSS \$5779 \$I72645 \$4664 \$6274 \$5851 VDD DFFR_X1
X$2487 VSS \$6001 \$I72988 \$6183 \$6387 \$5851 VDD DFFR_X1
X$2488 VSS \$6001 \$I72958 \$6387 \$6180 \$5851 VDD DFFR_X1
X$2489 VSS \$6001 \$I72748 \$3996 \$6183 \$5851 VDD DFFR_X1
X$2493 \$4822 \$4821 VSS VDD \$6287 NAND2_X1
X$2494 \$6287 VSS VDD \$6373 INV_X1
X$2499 VSS \$6001 \$I72588 \$6386 \$6277 \$5851 VDD DFFR_X1
X$2500 VSS \$6001 \$I72268 \$4677 \$6386 \$5851 VDD DFFR_X1
X$2504 \$4664 \$4865 VSS VDD \$6439 NAND2_X1
X$2507 \$4946 \$4865 VSS VDD \$6285 NAND2_X1
X$2508 \$6285 VSS VDD \$6480 INV_X1
X$2509 VSS \$6373 \$7035 \$6443 \$6478 \$6480 VDD FA_X1
X$2511 \$6444 VSS VDD \$6363 INV_X1
X$2512 \$4821 \$4865 VSS VDD \$6444 NAND2_X1
X$2513 VSS \$6360 \$6738 \$6578 \$6367 \$6363 VDD FA_X1
X$2514 \$4599 \$5635 VSS VDD \$6367 NOR2_X1
X$2515 \$4822 \$4759 VSS VDD \$6362 NAND2_X1
X$2516 \$6362 VSS VDD \$6360 INV_X1
X$2518 \$4822 \$4599 VSS VDD \$6288 NAND2_X1
X$2524 \$6288 VSS VDD \$6445 INV_X1
X$2525 \$4865 \$4759 VSS VDD \$6289 NAND2_X1
X$2526 \$6289 VSS VDD \$6447 INV_X1
X$2527 VSS \$6352 \$6354 \$6350 \$6351 \$6216 VDD FA_X1
X$2532 \$6350 VSS VDD \$6291 INV_X1
X$2533 VSS \$5916 \$6341 \$6331 \$6332 \$6210 VDD FA_X1
X$2538 \$6354 VSS VDD \$6745 INV_X1
X$2541 VSS \$5932 \$6449 \$6332 \$6291 \$6450 VDD FA_X1
X$2544 VSS \$6292 \$6796 \$6293 \$6331 \$6208 VDD FA_X1
X$2546 \$5917 \$6190 \$6589 VDD VSS \$6751 HA_X1
X$2550 \$6298 \$6294 VDD VSS \$6204 AND2_X1
X$2552 \$6008 VSS VDD \$6463 INV_X1
X$2555 \$6293 VSS VDD \$6451 INV_X1
X$2559 \$6016 \$6461 \$6191 VDD VSS \$6453 HA_X1
X$2560 \$5794 VSS VDD \$I56019 INV_X1
X$2563 \$6197 \$6191 VSS VDD \$6297 NAND2_X1
X$2564 \$6191 \$6200 \$6201 VSS VDD \$6296 NAND3_X1
X$2566 \$6194 \$6298 VSS VDD \$6018 NAND2_X1
X$2574 \$6297 \$6452 \$6296 VSS VDD \$6462 NAND3_X1
X$2575 \$6298 \$6454 VDD VSS \$6461 AND2_X1
X$2576 \$6953 \$6294 \$6194 \$6454 VDD \$6299 VSS NOR4_X2
X$2595 VSS \$2274 \$I72831 \$2881 \$3038 \$1003 VDD DFFR_X1
X$2596 VSS \$2274 \$I72898 \$3038 \$3035 \$1003 VDD DFFR_X1
X$2597 VSS \$2727 \$I72950 \$3043 \$2881 \$1914 VDD DFFR_X1
X$2598 VSS \$2727 \$I72943 \$3047 \$3043 \$1914 VDD DFFR_X1
X$2601 VSS \$2981 \$I72984 \$3055 \$2942 \$2883 VDD DFFR_X1
X$2604 VSS \$2982 \$2960 \$I65824 \$3057 \$2883 VDD DFFR_X1
X$2607 \$85 VSS VDD \$I74138 INV_X2
X$2608 \$1762 VSS VDD \$85 CLKBUF_X3
X$2612 \$2407 \$2641 \$2892 VSS VDD \$3144 NAND3_X1
X$2613 \$2960 \$2985 \$2894 VDD VSS \$2893 HA_X1
X$2614 \$2894 \$2407 \$2641 \$2958 VSS VDD \$2987 NAND4_X1
X$2615 \$2893 \$2894 \$3764 VSS \$2741 VDD AOI21_X1
X$2621 VSS \$3097 \$2994 \$3090 \$2362 \$3153 VDD FA_X1
X$2622 \$3090 VSS VDD \$2997 INV_X1
X$2624 \$1106 \$1558 VSS VDD \$3101 NAND2_X1
X$2640 VSS \$2725 \$I72406 \$3131 \$3024 \$1003 VDD DFFR_X1
X$2642 VSS \$2725 \$I72313 \$3184 \$3132 \$1003 VDD DFFR_X1
X$2643 VSS \$2725 \$I72900 \$3032 \$2928 \$1003 VDD DFFR_X1
X$2644 \$1545 VSS VDD \$2725 CLKBUF_X3
X$2649 VSS \$2725 \$I72259 \$2979 \$3032 \$1003 VDD DFFR_X1
X$2650 VSS \$2725 \$I72253 \$3035 \$2979 \$1003 VDD DFFR_X1
X$2654 VSS \$2727 \$I72502 \$3136 \$2635 \$2883 VDD DFFR_X1
X$2656 \$1545 VSS VDD \$2727 CLKBUF_X3
X$2659 VSS \$2727 \$I72465 \$3051 \$3047 \$2883 VDD DFFR_X1
X$2660 VSS \$2727 \$I72489 \$3054 \$3051 \$2883 VDD DFFR_X1
X$2661 VSS \$2981 \$I72469 \$3057 \$3054 \$2883 VDD DFFR_X1
X$2662 VSS \$1002 \$I72492 \$3141 \$3055 \$2883 VDD DFFR_X1
X$2669 \$3069 \$2984 \$2958 VDD VSS \$2986 HA_X1
X$2671 \$2742 \$2987 VSS VDD \$3225 OR2_X1
X$2674 \$3149 \$2991 VSS VDD \$2990 NAND2_X2
X$2679 \$2650 VSS VDD \$3151 INV_X1
X$2682 \$2243 VSS VDD \$3226 INV_X1
X$2684 \$3084 VSS VDD \$3152 INV_X1
X$2686 \$2652 VSS VDD \$2992 INV_X1
X$2687 VSS \$2995 \$3084 \$3440 \$3086 \$2994 VDD FA_X1
X$2688 \$2996 VSS VDD \$2995 INV_X1
X$2689 VSS \$3093 \$2996 \$3154 \$2717 \$2997 VDD FA_X1
X$2690 \$2245 \$643 VSS VDD \$2999 NAND2_X1
X$2694 \$2897 VSS VDD \$3000 INV_X1
X$2695 \$3101 VSS VDD \$3155 INV_X1
X$2698 \$2900 VSS VDD \$3395 INV_X1
X$2701 \$3106 VSS VDD \$3220 INV_X1
X$2703 \$643 \$2518 VDD VSS \$3156 AND2_X1
X$2705 \$2518 \$938 VSS VDD \$3002 NAND2_X1
X$2706 \$3002 VSS VDD \$3407 INV_X1
X$2708 \$3003 VSS VDD \$3218 INV_X1
X$2709 \$3114 \$938 VSS VDD \$3003 NAND2_X1
X$2710 \$817 \$2349 VSS VDD \$3409 NAND2_X1
X$2713 VSS \$2904 \$3005 \$2905 \$3006 \$2954 VDD FA_X1
X$2718 \$2901 VSS VDD \$3418 INV_X1
X$2720 \$3005 VSS VDD \$3216 INV_X1
X$2722 \$3121 VSS VDD \$3114 INV_X1
X$2723 VSS \$2472 \$3121 \$2245 \$3415 \$175 VDD DFFR_X1
X$2724 \$1106 \$2349 VSS VDD \$3123 NAND2_X1
X$2729 \$3123 VSS VDD \$3161 INV_X1
X$2730 \$2245 \$1655 VSS VDD \$3393 NAND2_X1
X$2732 \$3126 VSS VDD \$3162 INV_X1
X$2735 VSS \$2257 \$I72828 \$817 \$3687 \$175 VDD DFFR_X1
X$2739 \$3009 \$2907 \$2761 VDD VSS \$2908 HA_X1
X$2747 \$3275 VSS VDD \$2907 INV_X1
X$2751 VSS \$3166 \$3009 \$2909 \$3207 \$3010 VDD FA_X1
X$2753 \$3113 VSS VDD \$2946 INV_X1
X$2754 VSS \$3116 \$2910 \$2911 \$3118 \$2946 VDD FA_X1
X$2755 VSS \$2767 \$3113 \$3104 \$2531 \$2944 VDD FA_X1
X$2756 \$3104 VSS VDD \$3011 INV_X1
X$2758 VSS \$2914 \$2912 \$3092 \$3096 \$3085 VDD FA_X1
X$2759 \$3092 VSS VDD \$2937 INV_X1
X$2760 VSS \$3013 \$2769 \$2561 \$3197 \$2937 VDD FA_X1
X$2761 \$2918 VSS VDD \$3083 INV_X1
X$2766 \$3167 VSS VDD \$3118 INV_X1
X$2770 VSS \$3499 \$3116 \$2764 \$3205 \$3011 VDD FA_X1
X$2774 \$2913 VSS VDD \$3096 INV_X1
X$2778 \$3193 VSS VDD \$3013 INV_X1
X$2781 \$3079 \$3083 \$2531 VDD VSS \$2767 HA_X1
X$2782 \$3014 \$1580 VSS VDD \$3015 NAND2_X1
X$2784 \$3014 \$1586 VSS VDD \$2918 NAND2_X1
X$2785 \$3189 VSS VDD \$2936 INV_X1
X$2786 \$3063 VSS VDD \$2933 INV_X1
X$2791 \$3015 VSS VDD \$3079 INV_X1
X$2794 \$3314 VSS VDD \$3190 INV_X1
X$2795 \$3017 VSS VDD \$3172 INV_X1
X$2797 \$2921 \$1583 VSS VDD \$3017 NAND2_X1
X$2800 \$1475 \$3065 VSS VDD \$3018 NOR2_X1
X$2801 VSS \$3019 \$3063 \$2671 \$3018 \$3059 VDD FA_X1
X$2802 \$2921 \$1358 VSS VDD \$3044 NAND2_X1
X$2807 \$3044 VSS VDD \$3019 INV_X1
X$2809 VSS \$652 \$I72816 \$1475 \$3021 \$2922 VDD DFFR_X1
X$2810 VSS \$3020 \$I72964 \$2774 \$4099 \$2922 VDD DFFR_X1
X$2819 VSS \$3020 \$I72529 \$3021 \$3037 \$2922 VDD DFFR_X1
X$2833 VSS \$5064 \$I72729 \$5067 \$4975 \$1914 VDD DFFR_X1
X$2837 VSS \$4778 \$I72770 \$4891 \$5200 \$1914 VDD DFFR_X1
X$2838 VSS \$4778 \$I72783 \$4895 \$5232 \$4645 VDD DFFR_X1
X$2842 \$4539 \$5026 \$5072 VDD VSS \$4977 HA_X1
X$2846 \$4916 \$4839 VSS VDD \$4840 XOR2_X1
X$2847 VSS \$4538 \$I72924 \$5080 \$4840 \$4645 VDD DFFR_X1
X$2853 dxin[5] VSS VDD \$5106 BUF_X1
X$2857 VSS \$5064 \$I72327 \$5105 \$5106 \$1914 VDD DFFR_X1
X$2862 \$5064 VSS VDD CLKBUF_X1
X$2863 VSS \$5064 \$I72415 \$5292 \$5067 \$1914 VDD DFFR_X1
X$2868 \$4595 \$5129 \$5069 VDD VSS \$5070 HA_X1
X$2871 \$4977 \$5069 VSS VDD \$5071 NAND2_X1
X$2872 \$5071 \$5203 \$5246 VSS VDD \$5139 NAND3_X1
X$2873 \$5069 \$5072 \$5145 VSS VDD \$5246 NAND3_X1
X$2874 \$5139 \$5136 \$4916 VSS \$5134 VDD AOI21_X1
X$2875 \$4977 VSS VDD \$5073 INV_X1
X$2877 \$5148 \$5074 \$5075 VDD \$5145 VSS OAI21_X1
X$2878 \$5074 \$5152 \$5075 VDD \$5207 VSS OAI21_X1
X$2879 \$5079 \$4839 \$4916 VSS \$5152 VDD AOI21_X1
X$2880 \$5079 VSS VDD \$5148 INV_X1
X$2883 \$5079 \$4839 \$4911 VSS \$5078 VDD AOI21_X1
X$2884 \$4933 \$5080 VDD VSS \$4841 AND2_X1
X$2886 \$4488 VSS VDD \$4538 CLKBUF_X3
X$2887 \$4538 VSS VDD \$I56322 INV_X1
X$2891 \$4933 \$4980 VDD VSS \$4924 AND2_X1
X$2893 \$4980 \$4643 \$5040 \$4750 VSS VDD \$4981 NOR4_X1
X$2895 VSS \$4538 \$I72442 \$4980 \$4922 \$4645 VDD DFFR_X1
X$2897 \$5040 \$4933 VSS VDD \$4930 NAND2_X1
X$2901 VSS \$4937 \$I72618 \$5040 \$5043 \$4645 VDD DFFR_X1
X$2902 \$4983 VSS VDD \$5043 INV_X1
X$2903 VSS \$4937 \$I72658 \$4936 \$5046 \$3256 VDD DFFR_X1
X$2911 \$3965 VSS VDD \$4937 CLKBUF_X3
X$2914 VSS \$4848 \$I72880 \$5083 \$134 \$3256 VDD DFFR_X1
X$2923 VSS \$4848 \$I72303 \$5312 \$5083 \$5084 VDD DFFR_X1
X$2928 VSS \$4452 \$I72736 \$5190 \$5062 \$5084 VDD DFFR_X1
X$2929 VSS \$4957 \$I72649 \$4268 \$4991 \$3256 VDD DFFR_X1
X$2930 VSS \$4957 \$I72657 \$4519 \$4992 \$3256 VDD DFFR_X1
X$2933 VSS \$4853 \$I72785 \$5188 \$4752 \$4657 VDD DFFR_X1
X$2939 VSS \$4957 \$I72390 \$5085 \$5190 \$5084 VDD DFFR_X1
X$2940 VSS \$4957 \$I72521 \$5087 \$5085 \$5084 VDD DFFR_X1
X$2942 VSS \$4957 \$I72576 \$5192 \$5087 \$4657 VDD DFFR_X1
X$2945 VSS \$4853 \$I72392 \$5181 \$5192 \$4657 VDD DFFR_X1
X$2948 VSS \$5089 \$I72298 \$5091 \$5188 \$4657 VDD DFFR_X1
X$2949 VSS \$5089 \$I72307 \$5277 \$5091 \$4657 VDD DFFR_X1
X$2953 \$3685 VSS VDD \$4857 CLKBUF_X3
X$2955 VSS \$4994 \$I72829 \$4858 \$5267 \$4191 VDD DFFR_X1
X$2960 VSS \$4861 \$I72874 \$4826 \$5320 \$4191 VDD DFFR_X1
X$2961 \$3305 VSS VDD \$4861 CLKBUF_X3
X$2965 VSS \$4994 \$I72437 \$5178 \$5181 \$4657 VDD DFFR_X1
X$2969 VSS \$4861 \$I72294 \$5177 \$5178 \$4460 VDD DFFR_X1
X$2970 VSS \$4861 \$I72935 \$5056 \$5177 \$4460 VDD DFFR_X1
X$2972 VSS \$4995 \$I72978 \$4821 \$5056 \$4460 VDD DFFR_X1
X$2974 \$3305 VSS VDD \$4995 CLKBUF_X3
X$2975 \$4995 VSS VDD CLKBUF_X1
X$2983 VSS \$4995 \$I72301 \$5096 \$5172 \$4460 VDD DFFR_X1
X$2985 VSS \$4995 \$I72739 \$5035 \$4940 \$4460 VDD DFFR_X1
X$2986 VSS \$4914 \$I72382 \$4759 \$5096 \$4460 VDD DFFR_X1
X$2987 VSS \$4914 \$I72711 \$4999 \$5035 \$4460 VDD DFFR_X1
X$2992 \$3305 VSS VDD \$4914 CLKBUF_X3
X$2993 VSS \$4914 \$I72698 \$5031 \$4999 \$4460 VDD DFFR_X1
X$2995 VSS \$4914 \$I72696 \$4280 \$5031 \$4460 VDD DFFR_X1
X$3002 \$5098 VSS VDD \$5229 INV_X1
X$3003 \$5001 VSS VDD \$5025 INV_X1
X$3004 \$4821 \$4279 VSS VDD \$5001 NAND2_X1
X$3006 \$5025 \$4874 \$5014 VDD VSS \$5123 HA_X1
X$3008 \$4865 \$3294 VSS VDD \$5098 NAND2_X1
X$3011 \$4821 \$4281 VSS VDD \$5101 NAND2_X1
X$3013 \$5101 VSS VDD \$5102 INV_X1
X$3016 \$4599 \$3996 VSS VDD \$5128 NAND2_X1
X$3017 \$5128 VSS VDD \$5121 INV_X1
X$3018 VSS \$5122 \$5359 \$5118 \$5125 \$5121 VDD FA_X1
X$3019 \$4100 \$4392 VSS VDD \$5006 NAND2_X1
X$3022 \$5006 VSS VDD \$5122 INV_X1
X$3023 \$4876 VSS VDD \$5125 INV_X1
X$3024 \$4280 \$4677 VSS VDD \$4876 NAND2_X1
X$3028 VSS \$5014 \$5226 \$5007 \$5011 \$5012 VDD FA_X1
X$3033 \$4378 \$4881 \$5109 VDD VSS \$5008 HA_X1
X$3043 \$5118 \$5229 \$5117 VDD VSS \$5329 HA_X1
X$3046 \$5007 \$5117 \$5115 VDD VSS \$5344 HA_X1
X$3049 VSS \$5104 \$5219 \$5220 \$5115 \$5111 VDD FA_X1
X$3060 VSS \$3231 \$I72597 \$4105 \$3833 \$1914 VDD DFFR_X1
X$3076 VSS \$3231 \$I72322 \$4068 \$4105 \$1914 VDD DFFR_X1
X$3077 VSS \$3231 \$I72767 \$3777 \$3993 \$1914 VDD DFFR_X1
X$3082 \$1545 VSS VDD \$3668 CLKBUF_X3
X$3083 VSS \$3668 \$I72606 \$3781 \$3851 \$1914 VDD DFFR_X1
X$3088 VSS \$3668 \$I72289 \$3993 \$4068 \$1914 VDD DFFR_X1
X$3091 VSS \$3471 \$I72818 \$3737 \$3959 \$1914 VDD DFFR_X1
X$3092 VSS \$3471 \$I72796 \$3959 \$3855 \$1914 VDD DFFR_X1
X$3098 \$1545 VSS VDD \$3471 CLKBUF_X3
X$3100 VSS \$3471 \$I72346 \$4170 \$1920 \$2883 VDD DFFR_X1
X$3104 VSS \$3960 \$I72290 \$4073 \$3236 \$2883 VDD DFFR_X1
X$3105 VSS \$3960 \$I72554 \$4118 \$4073 \$2883 VDD DFFR_X1
X$3106 \$3965 VSS VDD \$3960 CLKBUF_X3
X$3107 \$3960 VSS VDD \$I56307 INV_X1
X$3110 VSS \$3960 \$I72389 \$4074 \$4118 \$2883 VDD DFFR_X1
X$3111 VSS \$3960 \$I72857 \$3963 \$3670 \$2883 VDD DFFR_X1
X$3116 VSS \$4028 \$I72455 \$4127 \$4074 \$2883 VDD DFFR_X1
X$3117 \$3965 VSS VDD \$4028 CLKBUF_X3
X$3123 \$4028 VSS VDD CLKBUF_X1
X$3124 VSS \$4028 \$I72421 \$4130 \$4127 \$3256 VDD DFFR_X1
X$3127 VSS \$4028 \$I72449 \$4143 \$4130 \$3256 VDD DFFR_X1
X$3132 \$4077 \$3873 VSS VDD \$4033 NOR2_X1
X$3133 \$3256 VSS VDD \$4077 INV_X1
X$3134 \$3968 VSS VDD \$2984 INV_X1
X$3135 \$4077 \$3564 VSS VDD \$4038 NOR2_X1
X$3137 VSS \$4050 \$3788 \$1756 \$4080 \$3671 VDD FA_X1
X$3138 \$3888 VSS VDD \$4050 INV_X1
X$3141 \$3794 VSS VDD \$3790 INV_X1
X$3142 \$3792 \$3791 VDD VSS \$3968 XNOR2_X1
X$3143 \$3793 VSS VDD \$4331 INV_X1
X$3144 \$3795 \$4165 VSS VDD \$4057 NAND2_X1
X$3145 \$4057 \$4160 \$4082 VSS \$3973 VDD AOI21_X1
X$3150 \$4077 \$3968 VSS VDD \$4070 NOR2_X1
X$3151 \$4078 VSS VDD \$2985 INV_X1
X$3154 \$3671 \$4080 \$4079 VDD VSS \$4176 HA_X1
X$3155 \$4143 \$4177 \$39 VDD VSS \$3888 HA_X1
X$3159 \$4082 \$4237 VDD VSS \$4078 XNOR2_X1
X$3160 \$3791 VSS VDD \$4084 INV_X1
X$3161 \$4084 \$4154 \$3790 VDD \$3971 VSS OAI21_X1
X$3162 \$4178 \$4237 \$4082 VSS \$4154 VDD AOI21_X1
X$3163 \$4083 \$4084 \$3790 VDD \$4179 VSS OAI21_X1
X$3164 \$4084 \$4180 \$3793 VSS VDD \$4160 NOR3_X1
X$3166 \$4086 \$4180 \$4083 \$4161 \$4156 VDD VSS \$3792 OAI221_X1
X$3169 \$4085 \$4337 VSS VDD \$4161 NAND2_X1
X$3171 \$4062 \$3911 \$3791 VDD VSS \$3794 HA_X1
X$3178 \$4063 VSS VDD \$4182 INV_X1
X$3180 \$4248 \$4086 \$4254 VSS VDD \$4082 NAND3_X1
X$3181 \$4148 \$4085 \$4183 VSS VDD \$4254 NAND3_X1
X$3182 \$4088 \$4186 \$4148 VDD VSS \$4187 HA_X1
X$3187 \$4090 \$3977 VDD VSS \$4233 XNOR2_X1
X$3188 \$3977 \$4090 VSS VDD \$3974 NAND2_X1
X$3190 \$3975 \$3974 VSS VDD \$3913 NAND2_X1
X$3191 \$4059 VSS VDD \$3975 INV_X1
X$3194 \$3976 \$3977 VSS VDD \$4053 NAND2_X1
X$3195 \$4053 \$3975 \$4044 VSS VDD \$3798 NAND3_X1
X$3196 \$3978 \$3977 \$4041 VSS VDD \$4044 NAND3_X1
X$3197 \$3801 \$4043 \$3978 VDD VSS \$3976 HA_X1
X$3198 \$3977 \$3978 \$3980 \$3981 VDD VSS \$3802 AND4_X1
X$3200 \$4091 \$3978 VDD VSS \$4141 AND2_X1
X$3201 \$4141 \$3976 VSS VDD \$4090 OR2_X1
X$3205 \$3980 VSS VDD \$4189 INV_X1
X$3206 \$4094 \$4189 \$4132 VDD \$4041 VSS OAI21_X1
X$3207 \$4132 \$4190 VSS VDD \$4091 NAND2_X1
X$3208 \$4126 VSS VDD \$4132 INV_X1
X$3210 \$3981 \$3937 \$3929 VSS VDD \$4095 NAND3_X1
X$3212 \$4019 \$3983 \$3980 VDD VSS \$4126 HA_X1
X$3215 \$4015 \$3948 \$3981 VDD VSS \$4017 HA_X1
X$3224 VSS \$4097 \$3016 \$4008 \$4370 \$2922 VDD DFFR_X1
X$3225 \$4008 VSS VDD \$3065 INV_X1
X$3229 \$4094 \$4095 VSS VDD \$4273 NAND2_X1
X$3231 \$4017 VSS VDD \$4094 INV_X1
X$3234 VSS \$4316 \$I72476 \$2109 \$4124 \$4191 VDD DFFR_X1
X$3245 VSS \$4119 \$I72585 \$4096 \$4192 \$4191 VDD DFFR_X1
X$3246 VSS \$4119 \$I72504 \$1959 \$4096 \$2922 VDD DFFR_X1
X$3249 VSS \$4097 \$I72423 \$3822 \$4281 \$2922 VDD DFFR_X1
X$3253 VSS \$3605 \$I72505 \$4112 \$4372 \$2922 VDD DFFR_X1
X$3254 VSS \$3605 \$I72953 \$3702 \$3996 \$2922 VDD DFFR_X1
X$3255 \$3605 VSS VDD \$I56148 INV_X1
X$3258 VSS \$3824 \$I72617 \$3703 \$3989 \$2922 VDD DFFR_X1
X$3269 VSS \$3605 \$I72551 \$4099 \$4279 \$2922 VDD DFFR_X1
X$3271 \$3824 VSS VDD \$I55617 INV_X1
X$3272 VSS \$3824 \$I72269 \$4108 \$4280 \$2922 VDD DFFR_X1
X$3273 \$4197 \$3294 \$4279 VDD VSS \$4102 AND3_X1
X$3275 \$4102 \$4200 \$4198 VDD VSS \$4386 HA_X1
X$3287 \$2132 VSS VDD \$2134 INV_X1
X$3289 \$2134 \$1843 \$2133 VDD VSS \$2135 HA_X1
X$3290 VSS \$2362 \$2366 \$2215 \$2214 \$2371 VDD FA_X1
X$3292 \$2377 VSS VDD \$2244 INV_X1
X$3294 \$2245 \$467 VSS VDD \$2377 NAND2_X1
X$3296 VSS \$2138 \$2214 \$2384 \$1534 \$2207 VDD FA_X1
X$3298 \$2382 \$643 VSS VDD \$2207 NAND2_X1
X$3300 \$2384 VSS VDD \$2142 INV_X1
X$3303 VSS \$2136 \$2132 \$2243 \$1844 \$2366 VDD FA_X1
X$3305 \$1334 VSS VDD \$2362 INV_X1
X$3306 \$1335 VSS VDD \$2371 INV_X1
X$3307 \$1939 \$2244 \$1334 VDD VSS \$1335 HA_X1
X$3310 VSS \$2392 \$2094 \$2182 \$2389 \$2183 VDD FA_X1
X$3311 \$2367 \$467 VSS VDD \$1940 NAND2_X1
X$3315 \$463 VSS VDD \$I74152 INV_X4
X$3318 VSS \$2257 \$I72832 \$2116 \$2344 \$175 VDD DFFR_X1
X$3323 \$817 \$1655 VSS VDD \$2387 NAND2_X1
X$3324 \$831 \$2107 VSS VDD \$2249 NAND2_X1
X$3327 VSS \$2472 \$2461 \$1106 \$2388 \$175 VDD DFFR_X1
X$3328 \$1762 VSS VDD \$463 CLKBUF_X3
X$3330 \$2355 VSS VDD \$2367 INV_X1
X$3333 \$2412 VSS VDD \$2349 INV_X1
X$3340 VSS \$652 \$I72793 \$1763 \$2338 \$175 VDD DFFR_X1
X$3342 \$2319 \$2146 \$1880 VSS \$2330 VDD AOI21_X1
X$3348 \$2330 \$2261 VDD VSS \$2338 XNOR2_X1
X$3350 \$2330 VSS VDD \$2444 INV_X1
X$3355 \$2319 \$2146 \$1950 VSS \$2570 VDD AOI21_X1
X$3356 \$2312 \$2262 \$2146 VDD VSS \$2319 HA_X1
X$3358 \$2263 VSS VDD \$2312 INV_X1
X$3360 \$2264 VSS VDD \$2171 INV_X1
X$3363 \$2300 VSS VDD \$2147 INV_X1
X$3365 VSS \$2167 \$2532 \$2297 \$2310 \$2150 VDD FA_X1
X$3366 \$2148 VSS VDD \$2310 INV_X1
X$3370 VSS \$2295 \$2300 \$2151 \$2298 \$2533 VDD FA_X1
X$3372 \$2151 VSS VDD \$1875 INV_X1
X$3376 \$2297 VSS VDD \$2290 INV_X1
X$3378 VSS \$2266 \$2295 \$2285 \$2287 \$2267 VDD FA_X1
X$3380 \$2154 \$2152 \$1367 VDD VSS \$1997 HA_X1
X$3410 \$1563 VSS VDD \$943 INV_X1
X$3412 \$1563 \$1564 VSS VDD \$1660 NAND2_X1
X$3413 \$1660 \$1661 \$1565 VDD \$1198 VSS OAI21_X1
X$3414 \$1808 VSS VDD \$1565 INV_X1
X$3415 \$1567 \$943 \$1239 VDD \$1808 VSS OAI21_X1
X$3419 \$1661 \$1564 VDD VSS \$1803 XNOR2_X1
X$3421 \$1662 VSS VDD \$1239 INV_X1
X$3422 \$1763 \$1655 \$1564 VDD VSS \$1810 HA_X1
X$3423 \$1564 VSS VDD \$1568 INV_X1
X$3424 \$1568 \$1613 \$1567 VDD \$1342 VSS OAI21_X1
X$3425 \$1793 \$1568 \$1567 \$1452 \$1454 VDD VSS \$1050 OAI221_X1
X$3426 \$1564 \$1570 VSS VDD \$1452 NAND2_X1
X$3427 \$1667 \$394 \$385 VSS VDD \$2412 NAND3_X1
X$3429 \$1668 \$1570 \$1571 VSS \$1613 VDD AOI21_X1
X$3430 \$1571 \$1573 VDD VSS \$1524 XNOR2_X1
X$3433 \$1810 VSS VDD \$1567 INV_X1
X$3437 \$1825 \$394 \$385 VSS VDD \$1666 NAND3_X1
X$3438 \$1667 \$1825 VSS VDD \$1112 NOR2_X1
X$3442 VSS \$1023 \$I72516 \$1667 \$1572 \$175 VDD DFFR_X1
X$3444 \$1570 VSS VDD \$1573 INV_X1
X$3446 \$1672 \$1785 \$1045 VSS \$1661 VDD AOI21_X1
X$3447 \$1573 \$1456 \$1516 VSS VDD \$1785 NOR3_X1
X$3448 \$1455 VSS VDD \$1456 INV_X1
X$3450 \$1764 \$1456 VDD VSS \$1572 XNOR2_X1
X$3453 \$1886 \$1793 \$1851 VSS VDD \$1672 NAND3_X1
X$3454 \$1570 \$1455 \$1770 VSS VDD \$1851 NAND3_X1
X$3458 \$553 VSS VDD \$I74146 INV_X4
X$3459 \$1762 VSS VDD \$553 CLKBUF_X3
X$3466 \$1674 \$1853 VDD VSS \$1882 XNOR2_X1
X$3467 \$1876 \$1675 \$1352 VSS \$1674 VDD AOI21_X1
X$3468 \$1853 \$1675 VSS VDD \$1758 NAND2_X1
X$3470 \$1758 VSS VDD \$1459 INV_X1
X$3472 \$1738 VSS VDD \$1598 INV_X1
X$3475 \$1872 VSS VDD \$1489 INV_X1
X$3476 \$1576 VSS VDD \$1463 INV_X1
X$3477 \$1677 \$1463 \$1594 VDD VSS \$1464 HA_X1
X$3483 \$1680 \$1580 VSS VDD \$1576 NAND2_X1
X$3485 \$1856 VSS VDD \$1677 INV_X1
X$3487 \$1583 \$1357 VSS VDD \$1679 NAND2_X1
X$3489 \$1679 VSS VDD \$1465 INV_X1
X$3490 \$1581 \$1476 VSS VDD \$1466 NAND2_X1
X$3491 \$1475 \$1578 VSS VDD \$1591 NAND2_X1
X$3497 \$1476 \$1583 VSS VDD \$1468 NAND2_X1
X$3498 \$1580 \$1581 VSS VDD \$1359 NAND2_X1
X$3500 \$1586 \$1680 VSS VDD \$1589 NAND2_X1
X$3504 \$1580 \$1583 VSS VDD \$1469 NAND2_X1
X$3508 \$1580 \$1358 VSS VDD \$1702 NAND2_X1
X$3510 \$1684 \$1587 \$1471 VDD VSS \$1588 HA_X1
X$3511 \$1586 \$1581 VSS VDD \$1470 NAND2_X1
X$3520 \$1702 VSS VDD \$1587 INV_X1
X$3522 \$1587 \$1475 \$1586 VDD VSS \$1690 AND3_X1
X$3524 \$1685 VSS VDD \$1684 INV_X1
X$3526 \$1586 \$1583 VSS VDD \$1685 NAND2_X1
X$3541 \$13388 VSS VDD \$I56004 INV_X1
X$3543 \$11316 VSS VDD \$13388 CLKBUF_X3
X$3554 \$13451 VSS VDD \$13501 INV_X1
X$3556 \$13451 \$13453 \$13455 VSS VDD \$13480 NAND3_X1
X$3557 \$13480 \$13452 VSS VDD \$13394 NAND2_X1
X$3558 \$13501 \$13454 VSS VDD \$13452 NAND2_X1
X$3559 \$13453 \$13455 VSS VDD \$13454 NAND2_X1
X$3575 VSS \$13388 \$I72918 \$8760 \$13495 \$5607 VDD DFFR_X1
X$3587 \$13476 VSS VDD \$13393 INV_X1
X$3589 \$13484 VSS VDD \$13391 INV_X1
X$3590 \$13395 \$13456 VSS VDD \$13453 NAND2_X1
X$3591 \$13456 \$13395 VSS VDD \$13455 OR2_X1
X$3592 \$13396 VSS VDD \$13508 INV_X1
X$3595 \$13470 VSS VDD \$13397 INV_X1
X$3598 VSS \$13334 \$13470 \$13398 \$12988 \$13382 VDD FA_X1
X$3601 VSS \$13334 \$13487 \$13489 \$12988 \$13458 VDD FA_X1
X$3608 \$13508 \$13509 \$13484 VDD VSS \$13476 HA_X1
X$3612 \$13517 \$13515 VDD VSS \$13456 XNOR2_X1
X$3614 \$13512 \$13520 VDD VSS \$13533 XNOR2_X1
X$3616 VSS \$13334 \$13520 \$13488 \$12988 \$13461 VDD FA_X1
X$3618 \$13489 VSS VDD \$13529 INV_X1
X$3621 VSS \$13279 \$13552 \$13435 \$13523 \$13529 VDD FA_X1
X$3623 \$13465 VSS VDD \$13523 INV_X1
X$3625 VSS \$13462 \$13491 \$13465 \$13500 \$13464 VDD FA_X1
X$3626 VSS \$13359 \$13504 \$13500 \$13281 \$13401 VDD FA_X1
X$3646 \$13504 VSS VDD \$13535 INV_X1
X$3682 VSS \$9272 \$9368 \$9369 \$9274 \$9467 VDD FA_X1
X$3683 \$9453 VSS VDD \$9467 INV_X1
X$3685 \$9137 \$5973 VSS VDD \$9642 NAND2_X1
X$3688 \$8760 \$5973 VSS VDD \$9377 NAND2_X1
X$3689 \$9377 VSS VDD \$9692 INV_X1
X$3691 \$9378 \$8963 \$9379 VDD VSS \$9381 HA_X1
X$3692 VSS \$9493 \$9380 \$9383 \$9490 \$9382 VDD FA_X1
X$3693 \$9385 VSS VDD \$9493 INV_X1
X$3706 VSS \$9010 \$9450 \$9453 \$9008 \$9061 VDD FA_X1
X$3710 \$9450 VSS VDD \$9800 INV_X1
X$3713 \$6674 \$8254 VDD VSS \$9739 AND2_X1
X$3714 \$9642 VSS VDD \$9688 INV_X1
X$3717 VSS \$9019 \$10187 \$9643 \$9474 \$9742 VDD FA_X1
X$3718 VSS \$9692 \$9948 \$9822 \$9375 \$9817 VDD FA_X1
X$3719 VSS \$9381 \$10189 \$9826 \$8590 \$9822 VDD FA_X1
X$3722 \$9383 \$9379 \$9698 VDD VSS \$9645 HA_X1
X$3726 VSS \$9282 \$9835 \$9843 \$9698 \$9840 VDD FA_X1
X$3729 VSS \$8710 \$I72705 \$9647 \$9504 \$7479 VDD DFFR_X1
X$3735 \$9647 VSS VDD \$9393 INV_X1
X$3738 \$9395 VSS VDD \$9080 INV_X4
X$3741 VSS \$9055 \$I72631 \$9538 \$9396 \$7479 VDD DFFR_X1
X$3742 \$9538 VSS VDD \$9880 INV_X1
X$3744 \$9544 VSS VDD \$9539 INV_X1
X$3747 VSS \$9716 \$I72604 \$9401 \$8975 \$7479 VDD DFFR_X1
X$3748 \$9395 \$9401 VDD VSS \$8918 AND2_X1
X$3750 \$9291 \$9711 \$9557 VDD VSS \$9090 HA_X1
X$3758 \$9647 \$9080 \$9745 VSS VDD NOR2_X4
X$3761 \$9649 \$9516 \$9648 VDD \$10199 VSS OAI21_X1
X$3762 \$9748 VSS VDD \$9648 INV_X1
X$3763 \$9857 VSS VDD \$9649 INV_X1
X$3765 \$8715 \$9649 VDD VSS \$9864 XNOR2_X1
X$3768 VSS \$8710 \$I72334 \$9651 \$9864 \$7479 VDD DFFR_X1
X$3771 \$9651 \$9647 \$9391 \$9752 VSS VDD \$9392 NAND4_X1
X$3772 \$9391 \$9752 VSS VDD \$9725 NOR2_X1
X$3773 \$9651 \$9393 VSS VDD \$9732 NOR2_X1
X$3774 \$9393 \$9753 \$9653 VSS VDD \$9530 NAND3_X1
X$3775 \$6665 VSS VDD \$9055 CLKBUF_X3
X$3776 \$9055 VSS VDD \$I55763 INV_X1
X$3778 \$9732 \$9725 \$9394 \$9714 VSS VDD \$9758 NAND4_X1
X$3782 \$9880 \$9080 VSS VDD \$8564 NOR2_X2
X$3788 VSS \$9716 \$I72589 \$9544 \$9879 \$7479 VDD DFFR_X1
X$3793 \$9401 \$9398 \$9657 \$9404 VSS VDD \$9714 NOR4_X1
X$3795 \$9395 \$9657 VDD VSS \$9711 AND2_X1
X$3796 VSS \$9288 \$I72326 \$9657 \$9557 \$7479 VDD DFFR_X1
X$3800 \$9766 \$9767 \$9658 VDD \$9659 VSS OAI21_X1
X$3801 \$9659 \$9768 VDD VSS \$8750 XNOR2_X1
X$3804 \$9570 \$9569 VDD VSS \$10471 XNOR2_X1
X$3807 \$9409 \$9572 VDD VSS \$9584 XNOR2_X1
X$3811 \$9622 \$9106 VSS VDD \$10121 XOR2_X1
X$3813 \$9614 \$9417 VDD VSS \$9419 XNOR2_X1
X$3818 \$9308 VSS VDD \$9420 INV_X1
X$3821 \$8635 \$9639 VDD VSS \$9421 XNOR2_X1
X$3822 \$9421 \$9120 VDD VSS \$9422 XNOR2_X1
X$3826 VSS \$10079 \$I72535 \$9660 \$9410 \$9773 VDD DFFR_X1
X$3831 VSS \$9771 \$I72262 \$9924 \$9414 \$9773 VDD DFFR_X1
X$3845 \$4619 VSS VDD \$9708 INV_X1
X$3846 \$9308 \$4619 \$9667 VSS VDD \$9775 NAND3_X1
X$3847 \$9420 \$9708 \$8636 VDD VSS \$9662 OAI21_X4
X$3850 \$9422 VSS VDD \$9780 INV_X1
X$3852 VSS \$9424 \$9640 \$9629 \$9631 \$9613 VDD FA_X1
X$3853 VSS \$9424 \$9639 \$9120 \$9631 \$9331 VDD FA_X1
X$3854 \$9629 VSS VDD \$9425 INV_X1
X$3857 \$9640 VSS VDD \$9423 INV_X1
X$3859 \$9427 VSS VDD \$9613 INV_X1
X$3862 \$9428 VSS VDD \$9590 INV_X1
X$3863 VSS \$9430 \$9427 \$9567 \$9429 \$9428 VDD FA_X1
X$3867 \$6156 \$9123 VSS VDD \$9428 NAND2_X1
X$3868 \$9429 VSS VDD \$9705 INV_X1
X$3869 \$5588 \$9123 VSS VDD \$9429 NAND2_X1
X$3872 \$9915 VSS VDD \$10020 INV_X1
X$3874 \$9434 \$8639 \$9435 VDD VSS \$9898 HA_X1
X$3875 VSS \$9439 \$9441 \$9434 \$8388 \$5920 VDD DFFR_X1
X$3877 \$9528 \$9435 VSS VDD \$8996 NAND2_X1
X$3878 \$9435 VSS VDD \$9545 INV_X1
X$3879 \$9545 \$8863 \$9436 VDD \$9670 VSS OAI21_X1
X$3887 \$9434 \$8636 \$9528 VDD VSS \$9669 HA_X1
X$3888 \$9528 VSS VDD \$9529 INV_X1
X$3889 \$9898 VSS VDD \$9436 INV_X1
X$3891 \$9669 VSS VDD \$9437 INV_X1
X$3892 \$9670 \$9529 VDD VSS \$9893 XNOR2_X1
X$3893 \$9669 \$9528 \$9670 VSS \$9671 VDD AOI21_X1
X$3897 VSS \$9439 \$I72486 \$9445 \$9893 \$5920 VDD DFFR_X1
X$3899 \$8705 VSS VDD \$9439 CLKBUF_X3
X$3902 \$9445 \$9443 \$9667 VSS VDD NOR2_X4
X$3904 \$9434 \$9123 \$9499 VDD VSS \$9862 HA_X1
X$3905 \$9676 \$9499 \$9315 VSS VDD \$9484 NAND3_X1
X$3906 \$9499 VSS VDD \$9442 INV_X1
X$3908 \$9443 VSS VDD \$6298 INV_X1
X$3910 \$9790 \$9481 \$9484 VSS VDD \$9444 NAND3_X1
X$3914 \$9434 \$9848 \$9676 VDD VSS \$9860 HA_X1
X$3918 \$9860 VSS VDD \$9481 INV_X1
X$3920 \$9819 \$9679 VSS VDD \$9443 NAND2_X2
X$3923 \$9448 \$9679 VDD \$9123 VSS AND2_X4
X$3925 \$9680 \$9681 VSS \$9679 VDD NAND2_X4
X$3927 \$9445 VSS VDD \$9458 INV_X2
X$3928 \$9447 \$9446 VSS \$9448 VDD OR2_X4
X$3936 \$9447 \$9445 \$9317 \$9446 VSS VDD \$9684 NAND4_X1
X$3937 VSS \$9448 \$9317 \$9445 \$9795 VDD NOR3_X4
X$3944 VSS \$9010 \$8821 \$8824 \$9008 \$8758 VDD FA_X1
X$3947 VSS \$8829 \$8757 \$7813 \$8759 \$8956 VDD FA_X1
X$3948 \$8660 VSS VDD \$8759 INV_X1
X$3949 \$8761 VSS VDD \$8829 INV_X1
X$3956 \$4173 VSS VDD err[2] BUF_X1
X$3959 VSS \$9010 \$9003 \$8104 \$9008 \$8757 VDD FA_X1
X$3963 \$9140 VSS VDD \$8956 INV_X1
X$3965 \$9137 \$6786 VSS VDD \$9140 NAND2_X1
X$3967 \$8760 \$6786 VSS VDD \$8761 NAND2_X1
X$3970 \$7649 \$5434 VSS VDD \$8762 NAND2_X1
X$3971 \$8762 VSS VDD \$8958 INV_X1
X$3973 \$6674 \$8760 VDD VSS \$9144 AND2_X1
X$3977 VSS \$8958 \$8957 \$8959 \$9020 \$9065 VDD FA_X1
X$3979 \$8840 VSS VDD \$9019 INV_X1
X$3982 \$7615 \$5129 VSS VDD \$9020 NOR2_X1
X$3985 \$7649 \$5026 VSS VDD \$8962 NAND2_X1
X$3986 \$8962 VSS VDD \$8963 INV_X1
X$3990 \$7613 \$5026 VSS VDD \$9040 NAND2_X1
X$3991 \$9137 \$5434 VSS VDD \$9068 NAND2_X1
X$3994 \$8106 \$6466 VSS VDD \$8966 NAND2_X1
X$3997 \$7915 \$5973 VSS VDD \$9160 NAND2_X1
X$3999 \$9174 VSS VDD \$8595 INV_X1
X$4002 \$8966 VSS VDD \$9034 INV_X1
X$4003 \$9160 VSS VDD \$9165 INV_X1
X$4004 \$8760 \$5434 VSS VDD \$9168 NAND2_X1
X$4005 \$9034 \$9165 \$9037 VDD VSS \$9836 HA_X1
X$4006 \$9040 VSS VDD \$9173 INV_X1
X$4007 VSS \$9037 \$8968 \$9072 \$8846 \$9070 VDD FA_X1
X$4009 \$8594 VSS VDD \$9043 INV_X1
X$4012 \$9073 VSS VDD \$8862 INV_X1
X$4014 \$8862 \$8596 \$8767 VDD \$9351 VSS OAI21_X1
X$4015 \$8767 \$8866 \$8970 \$8768 \$8867 VDD VSS \$8878 OAI221_X1
X$4016 \$9049 \$9073 VSS VDD \$8768 NAND2_X1
X$4023 \$9049 VSS VDD \$8866 INV_X1
X$4024 \$9074 VSS VDD \$8767 INV_X1
X$4025 \$9185 VSS VDD \$8970 INV_X1
X$4027 \$9051 \$9073 VDD VSS \$9054 XNOR2_X1
X$4031 \$8876 VSS VDD \$9081 INV_X1
X$4034 \$8971 VSS VDD \$9196 INV_X1
X$4035 \$9196 \$9080 VSS VDD \$8201 NOR2_X2
X$4036 \$8262 \$9080 VSS VDD \$8316 NOR2_X2
X$4039 VSS \$9055 \$I72412 \$9083 \$8771 \$7479 VDD DFFR_X1
X$4040 \$8890 \$8605 VDD VSS \$9396 XNOR2_X1
X$4044 VSS \$9055 \$I72594 \$9211 \$9052 \$7479 VDD DFFR_X1
X$4045 \$8774 \$8607 VSS VDD \$9052 XOR2_X1
X$4047 \$8601 \$8604 VDD VSS \$9879 XNOR2_X1
X$4050 \$8777 VSS VDD \$8973 INV_X1
X$4051 \$8777 \$8778 VSS VDD \$8906 NAND2_X1
X$4053 \$8779 \$9287 \$8777 VDD VSS \$8912 HA_X1
X$4054 \$8912 VSS VDD \$8610 INV_X1
X$4056 \$8917 \$9087 \$8915 VSS VDD \$8778 NAND3_X1
X$4058 \$8914 \$8780 VSS VDD \$8917 NAND2_X1
X$4059 \$8781 VSS VDD \$9087 INV_X1
X$4060 \$8780 \$8921 \$9090 VSS VDD \$8915 NAND3_X1
X$4061 \$8613 \$8978 \$8921 VDD VSS \$8914 HA_X1
X$4067 \$8778 \$8973 VDD VSS \$9047 XNOR2_X1
X$4068 \$9087 \$8973 \$8610 \$8976 \$8977 VDD VSS \$8774 OAI221_X1
X$4069 \$8777 \$8780 VSS VDD \$8976 NAND2_X1
X$4072 \$8977 \$8780 VDD VSS \$8975 XNOR2_X1
X$4076 VSS \$9222 \$8977 \$9039 \$9091 \$8919 VDD FA_X1
X$4078 VSS \$8611 \$I72727 \$4991 \$8930 \$7479 VDD DFFR_X1
X$4084 VSS \$8616 \$8933 \$9236 \$8936 \$8617 VDD FA_X1
X$4085 \$8783 \$8933 VDD VSS \$9234 XNOR2_X1
X$4086 \$8981 VSS VDD \$8936 INV_X1
X$4090 VSS \$8785 \$9247 \$9252 \$8943 \$8942 VDD FA_X1
X$4095 VSS \$8624 \$8982 \$9259 \$8623 \$8947 VDD FA_X1
X$4099 \$8786 \$8953 \$8787 VDD VSS \$9270 HA_X1
X$4102 \$9033 \$9234 VDD VSS \$9241 XNOR2_X1
X$4103 \$8122 \$8981 VDD VSS \$9033 XNOR2_X1
X$4104 \$9236 VSS VDD \$9093 INV_X1
X$4105 VSS \$9031 \$9242 \$9248 \$8784 \$8981 VDD FA_X1
X$4107 \$9247 VSS VDD \$9250 INV_X1
X$4110 \$9252 VSS VDD \$9095 INV_X1
X$4111 \$9251 VSS VDD \$9096 INV_X1
X$4115 \$8982 VSS VDD \$9098 INV_X1
X$4116 \$9028 VSS VDD \$9099 INV_X1
X$4120 \$9259 VSS VDD \$9261 INV_X1
X$4124 \$8983 VSS VDD \$9101 INV_X1
X$4127 \$9263 VSS VDD \$9266 INV_X1
X$4130 \$8627 \$9266 \$9106 VDD VSS \$9104 HA_X1
X$4135 \$9270 VSS VDD \$9107 INV_X1
X$4137 \$8446 \$8789 \$8788 VDD VSS \$8790 HA_X1
X$4141 \$8792 VSS VDD \$8791 INV_X1
X$4149 \$8632 VSS VDD \$8985 INV_X1
X$4150 \$8986 \$8985 \$8791 VDD \$9232 VSS OAI21_X1
X$4151 \$9232 \$9112 \$8634 VSS \$9110 VDD AOI21_X1
X$4152 \$8632 \$9115 VSS VDD \$9113 NAND2_X1
X$4153 \$9221 VSS VDD \$8986 INV_X1
X$4154 \$9027 \$8633 \$9115 VDD VSS \$9221 HA_X1
X$4155 \$8633 VSS VDD \$9216 INV_X1
X$4160 VSS \$8795 \$8987 \$8937 \$8793 \$8796 VDD FA_X1
X$4161 \$8937 VSS VDD \$9193 INV_X1
X$4165 \$8450 VSS VDD \$9027 INV_X1
X$4166 \$8634 VSS VDD \$9117 INV_X1
X$4170 \$8793 \$9204 VDD VSS \$9205 XNOR2_X1
X$4171 \$6624 \$9123 VSS VDD \$8794 NAND2_X1
X$4172 \$9121 VSS VDD \$8793 INV_X1
X$4173 VSS \$8989 \$9204 \$9119 \$9193 \$9120 VDD FA_X1
X$4174 VSS \$9022 \$8989 \$9122 \$9023 \$9121 VDD FA_X1
X$4176 \$8798 \$8931 VSS VDD \$8934 NOR2_X1
X$4177 \$8639 \$8798 VSS VDD \$8708 OR2_X1
X$4179 VSS \$8799 \$9022 \$8801 \$8909 \$8800 VDD FA_X1
X$4180 \$8798 \$8802 VSS VDD \$8909 NOR2_X1
X$4182 \$8803 \$8931 \$8804 VDD VSS \$8805 HA_X1
X$4183 \$8805 \$8804 \$8462 VSS \$8863 VDD AOI21_X1
X$4184 \$8805 \$8804 \$8807 VSS \$9314 VDD AOI21_X1
X$4186 \$8805 VSS VDD \$8810 INV_X1
X$4189 \$9181 VSS VDD \$9125 INV_X1
X$4193 \$5269 \$8931 VSS VDD \$8993 NAND2_X1
X$4194 \$8993 VSS VDD \$8799 INV_X1
X$4195 \$8801 VSS VDD \$9566 INV_X1
X$4199 \$8804 VSS VDD \$8811 INV_X1
X$4201 \$8688 \$8811 \$8810 VDD \$9128 VSS OAI21_X1
X$4202 \$8462 \$8811 VDD VSS \$8997 XNOR2_X1
X$4204 \$8811 \$8642 \$8996 VSS VDD \$8815 NOR3_X1
X$4206 VSS \$8644 \$I72540 \$8998 \$8997 \$5920 VDD DFFR_X1
X$4207 \$6298 \$8814 VDD VSS \$8802 AND2_X1
X$4208 VSS \$8644 \$I72625 \$8814 \$8848 \$5920 VDD DFFR_X1
X$4210 \$9007 \$8815 \$8469 VSS \$8835 VDD AOI21_X1
X$4212 \$8832 \$8815 VSS VDD \$8816 NAND2_X1
X$4213 \$8816 \$7770 \$8835 VDD \$9315 VSS OAI21_X1
X$4221 \$6298 \$8998 VDD VSS \$8931 AND2_X1
X$4222 \$9130 \$8681 \$8814 \$8998 VDD \$9000 VSS NOR4_X2
X$4226 VSS \$8818 \$9316 \$9000 \$6299 \$9681 VDD NAND4_X4
X$4248 VSS \$12135 \$12146 \$12140 \$12246 \$12187 VDD FA_X1
X$4250 \$12132 \$12134 \$12131 VDD VSS \$12330 HA_X1
X$4251 \$12282 VSS VDD \$12132 INV_X1
X$4252 \$12101 VSS VDD \$12134 INV_X1
X$4254 \$10615 \$12006 VSS VDD \$12101 NAND2_X1
X$4258 VSS \$12127 \$12243 \$12068 \$12237 \$12235 VDD FA_X1
X$4259 \$12121 VSS VDD \$12237 INV_X1
X$4261 \$11383 \$11191 VSS VDD \$12121 NAND2_X1
X$4265 VSS \$12281 \$12250 \$12187 \$12243 \$12330 VDD FA_X1
X$4269 \$10576 \$11635 VSS VDD \$12189 NAND2_X1
X$4270 \$12189 VSS VDD \$12235 INV_X1
X$4275 VSS \$11192 \$I72553 \$12288 \$12191 \$11529 VDD DFFR_X1
X$4276 \$12011 \$12007 \$11761 VSS \$12317 VDD AOI21_X1
X$4277 \$11761 \$12013 VDD VSS \$12191 XNOR2_X1
X$4284 \$12313 \$12214 VSS VDD \$11417 NOR2_X2
X$4287 \$12312 \$12214 VSS VDD \$11635 NOR2_X2
X$4290 \$12219 VSS VDD \$12312 INV_X1
X$4297 VSS \$12391 \$I72497 \$12216 \$12197 \$11529 VDD DFFR_X1
X$4298 VSS \$11531 \$I72944 \$12205 \$12106 \$11529 VDD DFFR_X1
X$4302 \$12216 VSS VDD \$12304 INV_X1
X$4303 \$12304 \$12214 VSS VDD \$11675 NOR2_X1
X$4304 \$12296 \$12214 VSS VDD \$12212 NOR2_X1
X$4307 \$12205 VSS VDD \$12296 INV_X1
X$4309 VSS \$11531 \$I72903 \$12199 \$12112 \$11529 VDD DFFR_X1
X$4311 \$11795 \$11775 VDD VSS \$12112 XNOR2_X1
X$4328 \$11450 \$12199 VDD VSS \$12200 AND2_X1
X$4394 dxin[6] VSS VDD \$5648 BUF_X1
X$4397 \$5607 VDD \$1914 VSS BUF_X4
X$4406 \$5506 VSS VDD \$I56236 INV_X1
X$4408 \$4488 VSS VDD \$5506 CLKBUF_X3
X$4414 VSS \$5961 \$I72420 \$6023 \$5609 \$5607 VDD DFFR_X1
X$4415 VSS \$5506 \$I72949 \$5294 \$5962 \$4645 VDD DFFR_X1
X$4419 \$5743 VSS VDD \$5661 INV_X1
X$4420 \$5236 \$5808 \$5663 VDD \$5743 VSS OAI21_X1
X$4421 \$5301 \$5674 \$5460 VDD VSS \$5668 HA_X1
X$4422 \$5668 VSS VDD \$5663 INV_X1
X$4430 \$5807 VSS VDD \$5874 INV_X1
X$4433 \$5460 VSS VDD \$5808 INV_X1
X$4435 \$5297 VSS VDD \$5935 INV_X1
X$4437 \$5297 \$5808 VDD VSS \$6042 XNOR2_X1
X$4441 VSS \$5612 \$I72371 \$5880 \$5610 \$4645 VDD DFFR_X1
X$4442 \$4933 \$5880 VDD VSS \$5434 AND2_X1
X$4446 VSS \$5612 \$I72304 \$5944 \$5748 \$4645 VDD DFFR_X1
X$4448 \$5678 VSS VDD \$5129 INV_X1
X$4449 \$5611 \$4933 VSS VDD \$5678 NAND2_X1
X$4452 \$5944 \$5611 \$5080 \$5307 VSS VDD \$5881 NOR4_X1
X$4456 VSS \$5464 \$5749 \$5751 \$5613 \$5689 VDD FA_X1
X$4457 VSS \$5835 \$5752 \$5832 \$5613 \$5615 VDD FA_X1
X$4461 \$5399 \$5476 VSS VDD \$5761 NAND2_X1
X$4462 \$5761 VSS VDD \$5762 INV_X1
X$4467 \$5476 \$5724 VSS VDD \$5765 NAND2_X1
X$4468 \$5765 VSS VDD \$5852 INV_X1
X$4469 VSS \$5618 \$5766 \$5859 \$5852 \$5716 VDD FA_X1
X$4474 VSS \$5620 \$I72806 \$5729 \$5473 \$5084 VDD DFFR_X1
X$4475 VSS \$5620 \$I72737 \$5621 \$5729 \$5084 VDD DFFR_X1
X$4477 VSS \$5620 \$I72956 \$5737 \$5621 \$5084 VDD DFFR_X1
X$4482 VSS \$5751 \$5882 \$5946 \$5885 \$5752 VDD FA_X1
X$4485 \$5833 VSS VDD \$5949 INV_X1
X$4488 \$5951 VSS VDD \$5886 INV_X1
X$4490 \$5399 \$5190 VSS VDD \$5887 NAND2_X1
X$4491 \$5473 \$5619 VSS VDD \$5951 NAND2_X1
X$4494 \$5190 \$5619 VSS VDD \$5890 NAND2_X1
X$4495 \$5842 VSS VDD \$5982 INV_X1
X$4496 \$5399 \$4752 VSS VDD \$5842 NAND2_X1
X$4499 VSS \$5762 \$6088 \$6096 \$5847 \$5892 VDD FA_X1
X$4500 \$4632 \$5467 VSS VDD \$5847 NOR2_X1
X$4502 \$5399 \$4632 VSS VDD \$5764 NAND2_X1
X$4503 \$5764 VSS VDD \$5986 INV_X1
X$4509 \$5766 VSS VDD \$5896 INV_X1
X$4512 \$5767 VSS VDD \$5716 INV_X1
X$4513 \$5399 \$4847 VSS VDD \$5898 NAND2_X1
X$4517 \$5399 \$5283 VSS VDD \$5901 NAND2_X1
X$4519 \$5620 VSS VDD CLKBUF_X1
X$4520 \$3965 VSS VDD \$5620 CLKBUF_X3
X$4523 VSS \$4853 \$I72941 \$5861 \$5737 \$4657 VDD DFFR_X1
X$4526 VSS \$5596 \$I72993 \$5773 \$303 \$4657 VDD DFFR_X1
X$4527 VSS \$5596 \$I72948 \$5734 \$5773 \$4657 VDD DFFR_X1
X$4533 VSS \$5625 \$I72677 \$5721 \$5734 \$4657 VDD DFFR_X1
X$4535 VSS \$5775 \$5860 \$5730 \$5732 \$5851 VDD DFFR_X1
X$4539 VSS \$5775 \$I72587 \$5778 \$5861 \$5851 VDD DFFR_X1
X$4540 VSS \$5775 \$I72762 \$5728 \$5730 \$4657 VDD DFFR_X1
X$4544 VSS \$5775 \$I72364 \$5857 \$5778 \$5851 VDD DFFR_X1
X$4545 VSS \$5779 \$I72491 \$5780 \$5857 \$5851 VDD DFFR_X1
X$4547 \$4657 VSS VDD \$5851 BUF_X1
X$4552 VSS \$5779 \$I72699 \$5711 \$5728 \$4657 VDD DFFR_X1
X$4556 VSS \$5483 \$I72786 \$5717 \$5721 \$4460 VDD DFFR_X1
X$4557 VSS \$5483 \$I72749 \$5709 \$5717 \$4460 VDD DFFR_X1
X$4560 VSS \$5325 \$I72979 \$4281 \$5709 \$4460 VDD DFFR_X1
X$4562 \$4664 \$4281 VSS VDD \$5829 NAND2_X1
X$4565 \$4946 \$4281 VSS VDD \$5787 NAND2_X1
X$4568 VSS \$5779 \$I72501 \$4946 \$5780 \$5851 VDD DFFR_X1
X$4574 \$5707 VSS VDD \$5483 CLKBUF_X3
X$4577 \$5325 VSS VDD \$I74126 INV_X2
X$4578 VSS \$5325 \$I72566 \$4279 \$5912 \$4460 VDD DFFR_X1
X$4579 \$4664 \$4279 VSS VDD \$5786 NAND2_X1
X$4580 \$5786 VSS VDD \$5913 INV_X1
X$4582 \$5829 VSS VDD \$6128 INV_X1
X$4583 VSS \$5786 \$5933 \$5811 \$5787 \$5692 VDD FA_X1
X$4585 VSS \$5825 \$5788 \$5672 \$5828 \$5637 VDD FA_X1
X$4589 VSS \$5791 \$5815 \$5664 \$5638 \$5669 VDD FA_X1
X$4590 \$4821 \$3996 VSS VDD \$5792 NAND2_X1
X$4591 \$5792 VSS VDD \$5669 INV_X1
X$4602 \$5788 VSS VDD \$5932 INV_X1
X$4607 \$5815 VSS VDD \$6007 INV_X1
X$4609 \$4759 \$4392 VSS VDD \$5790 NAND2_X1
X$4610 \$5790 VSS VDD \$5791 INV_X1
X$4612 \$5806 VSS VDD \$5916 INV_X1
X$4615 \$5811 VSS VDD \$5800 INV_X1
X$4618 VSS \$5800 \$6082 \$5928 \$5793 \$5350 VDD FA_X1
X$4619 VSS \$5798 \$6009 \$5918 \$5653 \$5928 VDD FA_X1
X$4621 VSS \$5794 \$I72263 \$6016 \$5498 \$5920 VDD DFFR_X1
X$4622 VSS \$5794 \$5921 \$5922 \$5642 \$5920 VDD DFFR_X1
X$4626 \$5795 VSS VDD \$5923 INV_X1
X$4635 xin[1] VSS VDD \$10933 BUF_X1
X$4638 VSS \$11266 \$I72799 \$10980 \$10933 \$5607 VDD DFFR_X1
X$4641 \$11207 VSS VDD \$8407 INV_X1
X$4645 \$10755 \$10982 VSS VDD \$11056 NAND2_X1
X$4646 \$11056 VSS VDD \$10993 INV_X1
X$4658 \$10755 VSS VDD \$11173 INV_X1
X$4661 \$10991 \$10993 VSS VDD \$11100 NAND2_X1
X$4662 \$10984 \$10993 \$10996 VSS \$11101 VDD AOI21_X1
X$4665 \$10986 \$11173 \$11101 \$11100 \$10936 VDD VSS \$11220 OAI221_X1
X$4666 \$10756 \$10991 \$11108 VSS \$11172 VDD AOI21_X1
X$4667 \$10935 \$11060 \$10934 VDD \$10996 VSS OAI21_X1
X$4668 \$10756 VSS VDD \$10934 INV_X1
X$4669 \$10935 \$10936 VSS VDD \$11108 NAND2_X1
X$4673 \$8344 \$11005 VDD VSS \$11062 XNOR2_X1
X$4674 \$10937 \$9997 VSS VDD \$11005 NAND2_X1
X$4677 VSS \$10938 \$I72997 \$11010 \$8254 \$10454 VDD DFFR_X1
X$4679 \$10991 VSS VDD \$11060 INV_X1
X$4682 \$11108 \$11060 VDD VSS \$12814 XNOR2_X1
X$4686 \$11062 \$11220 VDD VSS \$11270 XNOR2_X1
X$4689 VSS \$11063 \$I72813 \$10941 \$11010 \$10454 VDD DFFR_X1
X$4692 \$10540 VSS VDD CLKBUF_X1
X$4693 VSS \$11063 \$I72810 \$11019 \$10941 \$10454 VDD DFFR_X1
X$4694 VSS \$10540 \$I72667 \$10203 \$11019 \$10454 VDD DFFR_X1
X$4696 \$11027 VSS VDD \$11142 INV_X1
X$4697 VSS \$10949 \$11027 \$11033 \$11145 \$10945 VDD FA_X1
X$4698 \$10946 \$8319 VSS VDD \$10949 NAND2_X1
X$4701 \$10950 VSS VDD \$11040 INV_X1
X$4703 \$11070 VSS VDD \$11039 INV_X1
X$4706 \$11040 \$11072 \$10951 VDD VSS \$11073 HA_X1
X$4707 \$10951 \$10766 VSS VDD \$11074 NAND2_X1
X$4708 \$10766 \$10951 VDD VSS \$11075 XNOR2_X1
X$4715 \$7670 VSS VDD \$10540 CLKBUF_X3
X$4719 VSS \$10540 \$I72548 \$11071 \$10944 \$10454 VDD DFFR_X1
X$4720 \$10601 \$8520 VSS VDD \$11066 NAND2_X1
X$4721 \$11066 VSS VDD \$11252 INV_X1
X$4722 VSS \$11141 \$11149 \$11260 \$11142 \$11067 VDD FA_X1
X$4725 \$11468 \$8564 VSS VDD \$11145 NAND2_X1
X$4729 \$11279 \$11260 \$11070 VDD VSS \$11150 HA_X1
X$4730 VSS \$11150 \$11262 \$11072 \$11280 \$11149 VDD FA_X1
X$4736 \$11155 \$11074 VSS VDD \$11503 NAND2_X1
X$4737 \$11073 VSS VDD \$11155 INV_X1
X$4739 \$11075 VSS VDD \$11181 INV_X1
X$4742 \$10360 VSS VDD \$10208 BUF_X2
X$4744 VSS \$11282 \$I72884 \$10954 \$11850 \$10360 VDD DFFR_X1
X$4747 VSS \$11284 \$I72994 \$10213 \$11050 \$10208 VDD DFFR_X1
X$4752 VSS \$11282 \$I72475 \$11050 \$13075 \$10208 VDD DFFR_X1
X$4754 \$11077 VSS VDD \$10886 INV_X1
X$4758 \$11231 VSS VDD \$10895 INV_X1
X$4760 \$11164 VSS VDD \$11078 INV_X1
X$4763 \$10957 VSS VDD \$11080 INV_X1
X$4765 \$11165 \$10576 \$10960 VSS VDD \$10957 NAND3_X1
X$4768 \$11078 \$11167 VSS VDD \$11187 NAND2_X1
X$4769 \$11079 \$11158 VSS VDD \$11167 NAND2_X1
X$4770 \$11080 \$11188 \$11079 VDD VSS \$11164 HA_X1
X$4771 \$11159 \$11253 \$11165 VDD VSS \$11158 HA_X1
X$4772 \$11047 \$10959 \$10960 VDD VSS \$11159 AND3_X1
X$4777 \$11190 \$11047 \$11253 VDD VSS \$11290 HA_X1
X$4778 \$11157 VSS VDD \$11047 INV_X1
X$4779 \$10615 \$11191 VSS VDD \$11157 NAND2_X1
X$4780 \$10576 \$11191 VSS VDD \$11081 NAND2_X1
X$4781 \$11081 VSS VDD \$11247 INV_X1
X$4784 VSS \$11192 \$I72669 \$10961 \$10959 \$10208 VDD DFFR_X1
X$4786 VSS \$10962 \$I72899 \$10964 \$11239 \$10208 VDD DFFR_X1
X$4789 VSS \$10962 \$I72982 \$10918 \$11042 \$10208 VDD DFFR_X1
X$4790 VSS \$10778 \$I72609 \$10966 \$11082 \$10208 VDD DFFR_X1
X$4791 VSS \$10778 \$I72968 \$10734 \$10966 \$10208 VDD DFFR_X1
X$4796 \$10969 \$11028 VDD VSS \$11029 XNOR2_X1
X$4798 \$10968 VSS VDD \$11028 INV_X1
X$4799 \$10968 \$10969 VSS VDD \$11084 NAND2_X1
X$4800 \$11022 \$11084 VSS VDD \$10223 NAND2_X1
X$4801 \$11016 VSS VDD \$11022 INV_X1
X$4802 \$10971 \$11015 \$10968 VDD VSS \$11016 HA_X1
X$4812 \$10778 VSS VDD \$I74118 INV_X2
X$4813 \$10339 VSS VDD \$10778 CLKBUF_X3
X$4815 VSS \$10778 \$I72273 \$11234 \$10967 \$10208 VDD DFFR_X1
X$4820 \$9118 VSS VDD \$11233 INV_X1
X$4823 \$11021 VSS VDD \$10971 INV_X1
X$4825 VSS \$11136 \$11021 \$11085 \$11014 \$11013 VDD FA_X1
X$4826 VSS \$11134 \$11013 \$11086 \$11009 \$11012 VDD FA_X1
X$4827 VSS \$10919 \$11012 \$11133 \$11011 \$8798 VDD FA_X1
X$4830 \$11140 \$11196 VSS VDD \$10969 NAND2_X1
X$4832 \$11137 VSS VDD \$11140 INV_X1
X$4833 \$11085 VSS VDD \$11230 INV_X1
X$4836 VSS \$11128 \$11136 \$11363 \$10405 \$11086 VDD FA_X1
X$4839 \$11133 VSS VDD \$11345 INV_X1
X$4842 \$10782 VSS VDD \$11009 INV_X1
X$4845 \$11125 VSS VDD \$11128 INV_X1
X$4847 \$11007 VSS VDD \$10784 INV_X1
X$4850 VSS \$10863 \$11125 \$11088 \$10525 \$11004 VDD FA_X1
X$4852 \$10788 VSS VDD \$11219 INV_X1
X$4854 \$11002 VSS VDD \$11123 INV_X1
X$4856 \$11001 VSS VDD \$11089 INV_X1
X$4860 VSS \$11089 \$11225 \$11197 \$11123 \$11219 VDD FA_X1
X$4862 \$10233 \$11090 \$11333 VDD VSS \$11215 HA_X1
X$4863 \$10999 VSS VDD \$11090 INV_X1
X$4867 \$10849 \$10792 \$11119 VDD VSS \$11120 HA_X1
X$4870 \$10793 VSS VDD \$11212 INV_X1
X$4871 \$10972 VSS VDD \$11091 INV_X1
X$4876 \$11091 \$11212 \$11324 VDD VSS \$11118 HA_X1
X$4877 \$10990 \$10794 \$11114 VDD VSS \$11115 HA_X1
X$4882 \$10508 \$10973 \$11111 VDD VSS \$11093 HA_X1
X$4883 VSS \$11114 \$11092 \$10973 \$10979 \$10985 VDD FA_X1
X$4884 VSS \$10798 \$11094 \$11095 \$11111 \$10643 VDD FA_X1
X$4892 \$11092 VSS VDD \$11206 INV_X1
X$4897 \$11093 VSS VDD \$11204 INV_X1
X$4900 \$11094 \$11201 \$11105 VDD VSS \$11202 HA_X1
X$4901 \$11105 \$11095 \$10645 VSS VDD \$11306 NAND3_X1
X$4914 xin[4] VSS VDD \$11169 BUF_X1
X$4916 VSS \$11266 \$I72965 \$11171 \$11169 \$5607 VDD DFFR_X1
X$4918 VSS \$11266 \$11207 \$9137 \$11171 \$5607 VDD DFFR_X1
X$4932 \$11266 VSS VDD \$I55864 INV_X1
X$4933 \$11316 VSS VDD \$11266 CLKBUF_X3
X$4938 \$11172 \$10982 VDD VSS \$11323 XNOR2_X1
X$4939 \$11318 \$11172 \$10986 VDD \$11269 VSS OAI21_X1
X$4940 \$10982 VSS VDD \$11318 INV_X1
X$4941 \$11269 \$11173 VDD VSS \$12772 XNOR2_X1
X$4950 VSS \$11489 \$I72369 \$11542 \$7649 \$10454 VDD DFFR_X1
X$4953 VSS \$10938 \$I72431 \$11337 \$9137 \$10454 VDD DFFR_X1
X$4955 VSS \$10938 \$I73003 \$11338 \$8106 \$10454 VDD DFFR_X1
X$4956 VSS \$11063 \$I72801 \$11340 \$11338 \$10454 VDD DFFR_X1
X$4960 VSS \$11063 \$I72338 \$11556 \$11337 \$10454 VDD DFFR_X1
X$4961 \$7670 VSS VDD \$11063 CLKBUF_X3
X$4963 VSS \$11063 \$I72854 \$11347 \$11340 \$10454 VDD DFFR_X1
X$4967 VSS \$10540 \$I72951 \$10201 \$11347 \$10454 VDD DFFR_X1
X$4969 \$10201 \$9192 VSS VDD \$11275 NAND2_X1
X$4970 \$11275 VSS VDD \$11353 INV_X1
X$4972 \$11353 \$11252 \$11141 VDD VSS \$11355 HA_X1
X$4978 VSS \$11465 \$11367 \$11370 \$11360 \$11355 VDD FA_X1
X$4979 VSS \$11278 \$11360 \$11369 \$11473 \$11365 VDD FA_X1
X$4980 \$11276 VSS VDD \$11365 INV_X1
X$4981 \$10203 \$8201 VSS VDD \$11276 NAND2_X1
X$4982 \$10946 \$8316 VSS VDD \$11277 NAND2_X1
X$4983 \$11277 VSS VDD \$11278 INV_X1
X$4989 \$11500 \$11369 \$11279 VDD VSS \$11409 HA_X1
X$4994 VSS \$9716 \$I72920 \$11182 \$11371 \$10360 VDD DFFR_X1
X$4995 \$11071 \$11181 \$11371 VDD VSS \$11749 HA_X1
X$4996 VSS \$9716 \$I72701 \$11281 \$11182 \$10208 VDD DFFR_X1
X$5000 VSS \$11284 \$I72991 \$10733 \$11283 \$10208 VDD DFFR_X1
X$5002 VSS \$11284 \$I72892 \$11184 \$11183 \$10208 VDD DFFR_X1
X$5005 \$11257 \$11185 VSS VDD \$11288 NAND2_X1
X$5006 \$11186 VSS VDD \$11257 INV_X1
X$5008 \$11391 \$11397 \$11187 VSS VDD \$11185 NAND3_X1
X$5014 \$11281 \$11412 \$10467 VDD VSS \$11485 HA_X1
X$5016 \$11376 VSS VDD \$11282 CLKBUF_X3
X$5019 VSS \$11282 \$I72355 \$11379 \$11483 \$10360 VDD DFFR_X1
X$5020 \$11379 \$11414 \$10113 VDD VSS \$10610 HA_X1
X$5021 VSS \$11284 \$I72485 \$11183 \$11286 \$10208 VDD DFFR_X1
X$5024 \$11394 \$11476 \$11391 VDD VSS \$11186 HA_X1
X$5025 VSS \$11396 \$11394 \$11397 \$11472 \$11400 VDD FA_X1
X$5027 \$11401 \$11250 \$11188 VDD VSS \$11396 HA_X1
X$5029 \$11403 VSS VDD \$11190 INV_X1
X$5033 \$11245 \$11247 \$11401 VDD VSS \$11291 HA_X1
X$5034 \$11389 VSS VDD \$11245 INV_X1
X$5035 \$11292 \$10960 VSS VDD \$11389 NAND2_X1
X$5037 VSS \$11192 \$I72896 \$11239 \$11292 \$10208 VDD DFFR_X1
X$5038 VSS \$10962 \$I72882 \$11042 \$11383 \$10208 VDD DFFR_X1
X$5044 \$10959 \$11417 VSS VDD \$11403 NAND2_X1
X$5045 \$11290 \$11464 \$11250 VDD VSS \$11400 HA_X1
X$5049 \$11294 VSS VDD \$11643 INV_X1
X$5051 VSS \$10962 \$I72973 \$11082 \$11295 \$10208 VDD DFFR_X1
X$5057 \$9924 \$11191 \$11297 VDD VSS \$11419 HA_X1
X$5061 \$9969 \$10960 \$11296 VDD VSS \$11372 HA_X1
X$5069 \$11372 \$11297 VSS VDD \$11420 NAND2_X1
X$5076 \$11372 VSS VDD \$11422 INV_X1
X$5083 \$10779 \$11451 \$11562 VDD VSS \$11654 HA_X1
X$5085 \$11299 \$11195 VDD VSS \$11231 XNOR2_X1
X$5087 \$11195 \$11299 VSS VDD \$11196 NAND2_X1
X$5089 \$11228 \$11230 \$11195 VDD VSS \$11137 HA_X1
X$5094 \$11357 VSS VDD \$11228 INV_X1
X$5098 VSS \$11345 \$11342 \$11301 \$11225 \$11215 VDD FA_X1
X$5103 VSS \$11351 \$11357 \$11344 \$11363 \$11300 VDD FA_X1
X$5104 \$11344 VSS VDD \$11429 INV_X1
X$5105 \$11342 VSS VDD \$11300 INV_X1
X$5108 \$11349 VSS VDD \$11351 INV_X1
X$5109 VSS \$11336 \$11349 \$11546 \$11088 \$11301 VDD FA_X1
X$5112 \$11197 \$11218 \$11330 VDD VSS \$11336 HA_X1
X$5114 VSS \$11333 \$11302 \$11325 \$10789 \$11118 VDD FA_X1
X$5117 VSS \$11324 \$11444 \$11304 \$11303 \$11115 VDD FA_X1
X$5122 VSS \$11120 \$11430 \$11535 \$11330 \$11325 VDD FA_X1
X$5125 \$11119 \$11304 \$11322 VDD VSS \$11433 HA_X1
X$5128 \$11322 VSS VDD \$11311 INV_X1
X$5129 \$11200 \$11199 VDD VSS \$11077 XNOR2_X1
X$5131 \$11199 \$11200 VSS VDD \$11434 NAND2_X1
X$5133 VSS \$11204 \$11305 \$11309 \$11311 \$11206 VDD FA_X1
X$5135 \$11312 \$11441 \$11199 VDD VSS \$11440 HA_X1
X$5137 \$11305 VSS VDD \$11312 INV_X1
X$5140 \$11309 VSS VDD \$11201 INV_X1
X$5142 \$11307 \$11306 VSS VDD \$11200 NAND2_X1
X$5143 \$11202 VSS VDD \$11307 INV_X1
X$5162 dxin[4] VSS VDD \$3707 BUF_X1
X$5163 VSS \$3231 \$I72616 \$3827 \$3707 \$1914 VDD DFFR_X1
X$5166 VSS \$3231 \$I72615 \$3713 \$3712 \$1914 VDD DFFR_X1
X$5167 VSS \$3232 \$I72777 \$3667 \$3713 \$1914 VDD DFFR_X1
X$5168 VSS \$3232 \$I72599 \$3846 \$3667 \$1914 VDD DFFR_X1
X$5173 \$1914 VSS VDD \$2883 BUF_X2
X$5178 dxin[2] VSS VDD \$3828 BUF_X1
X$5179 VSS \$3231 \$I72397 \$3833 \$3827 \$1914 VDD DFFR_X1
X$5183 \$1545 VSS VDD \$3231 CLKBUF_X3
X$5187 VSS \$3232 \$I72283 \$3712 \$3777 \$1914 VDD DFFR_X1
X$5190 VSS \$3668 \$I72264 \$3851 \$3846 \$1914 VDD DFFR_X1
X$5191 \$3668 VSS VDD CLKBUF_X1
X$5192 VSS \$3668 \$I72299 \$3855 \$3781 \$1914 VDD DFFR_X1
X$5196 VSS \$2981 \$I72875 \$3613 \$3737 \$2883 VDD DFFR_X1
X$5199 VSS \$3960 \$I72843 \$3864 \$3614 \$2883 VDD DFFR_X1
X$5205 VSS \$3785 \$3671 \$I65759 \$3754 \$3256 VDD DFFR_X1
X$5211 VSS \$3960 \$I72388 \$3783 \$3864 \$2883 VDD DFFR_X1
X$5212 VSS \$4028 \$I72561 \$3784 \$3783 \$2883 VDD DFFR_X1
X$5213 VSS \$4028 \$I72453 \$3869 \$3784 \$2883 VDD DFFR_X1
X$5215 VSS \$3785 \$3876 \$I65676 \$3869 \$3256 VDD DFFR_X1
X$5221 \$3876 \$3878 \$3786 VDD VSS \$3787 HA_X1
X$5222 \$3786 \$3788 VSS VDD \$3672 NOR2_X1
X$5223 \$3762 \$3566 VSS VDD \$3764 NAND2_X1
X$5224 \$3787 VSS VDD \$3762 INV_X1
X$5227 \$3774 \$3675 VDD VSS \$3564 XNOR2_X1
X$5228 \$3673 \$3674 \$3767 VDD \$3774 VSS OAI21_X1
X$5229 \$3676 VSS VDD \$3673 INV_X1
X$5231 \$3786 \$3788 VSS VDD \$3566 NAND2_X1
X$5232 \$3787 \$3786 \$3887 VSS \$2742 VDD AOI21_X1
X$5233 \$4079 VSS VDD \$3789 INV_X1
X$5234 \$3888 \$3789 \$4081 VDD \$3887 VSS OAI21_X1
X$5239 \$3971 \$3676 VDD VSS \$3873 XNOR2_X1
X$5241 \$3794 \$3791 \$3792 VSS \$3674 VDD AOI21_X1
X$5242 \$3676 \$3675 VSS VDD \$3793 NAND2_X1
X$5243 \$3773 VSS VDD \$3795 INV_X1
X$5245 \$3767 \$3769 \$3567 VDD \$3773 VSS OAI21_X1
X$5246 \$3675 VSS VDD \$3769 INV_X1
X$5247 \$3909 VSS VDD \$3767 INV_X1
X$5248 \$3760 \$3765 \$3676 VDD VSS \$3909 HA_X1
X$5250 \$3570 VSS VDD \$3765 INV_X1
X$5253 \$3573 \$3913 VSS VDD \$3761 NAND2_X1
X$5256 \$3679 \$3757 \$3921 VSS VDD \$3247 NAND3_X1
X$5260 \$3651 \$3798 VSS VDD \$3757 NAND2_X1
X$5262 VSS \$3681 \$3799 \$3800 \$3758 \$3575 VDD FA_X1
X$5269 \$3571 VSS VDD \$3911 INV_X1
X$5272 \$3913 \$3573 VDD VSS \$4063 XNOR2_X1
X$5276 \$3920 VSS VDD \$3797 INV_X1
X$5277 \$3923 \$3797 \$3977 VDD VSS \$4059 HA_X1
X$5278 \$3799 VSS VDD \$3923 INV_X1
X$5282 \$3800 VSS VDD \$4043 INV_X1
X$5285 \$3931 VSS VDD \$3801 INV_X1
X$5288 \$3929 \$3937 \$3651 \$3802 VSS VDD \$3921 NAND4_X1
X$5289 VSS \$3943 \$3931 \$3942 \$3753 \$3682 VDD FA_X1
X$5296 \$3942 VSS VDD \$3983 INV_X1
X$5298 VSS \$3952 \$4019 \$3948 \$3945 \$3577 VDD FA_X1
X$5299 \$3748 VSS VDD \$3943 INV_X1
X$5301 \$3642 \$3750 \$3945 VDD VSS \$3748 HA_X1
X$5302 \$1762 VSS VDD \$3685 CLKBUF_X3
X$5303 \$2905 \$3747 \$3803 VDD VSS \$3952 HA_X1
X$5307 VSS \$3745 \$4015 \$3937 \$3803 \$3634 VDD FA_X1
X$5310 \$3742 \$3744 \$3806 VDD VSS \$3741 HA_X1
X$5311 \$3272 \$3686 \$3744 VDD VSS \$3745 HA_X1
X$5312 \$3741 VSS VDD \$3946 INV_X1
X$5316 \$3946 \$3805 VSS VDD \$3929 NAND2_X1
X$5317 \$3806 \$3163 VSS VDD \$3805 NAND2_X1
X$5323 \$3950 \$3941 VDD VSS \$3738 XNOR2_X1
X$5325 VSS \$3688 \$3527 \$3735 \$3578 \$3732 VDD FA_X1
X$5328 VSS \$3692 \$3628 \$3449 \$3578 \$3689 VDD FA_X1
X$5331 \$3915 VSS VDD \$3579 INV_X1
X$5332 \$3690 VSS VDD \$3808 INV_X1
X$5337 \$3930 \$3927 VDD VSS \$3941 XNOR2_X1
X$5338 \$3927 VSS VDD \$3688 INV_X1
X$5339 \$3912 \$3808 \$3927 VDD VSS \$3930 HA_X1
X$5344 \$3919 VSS VDD \$3689 INV_X1
X$5346 VSS \$3807 \$3919 \$3915 \$3892 \$3808 VDD FA_X1
X$5348 \$3725 VSS VDD \$3807 INV_X1
X$5349 VSS \$3895 \$3732 \$3692 \$3690 \$3691 VDD FA_X1
X$5350 \$3723 VSS VDD \$3624 INV_X1
X$5353 \$3014 \$3065 \$3691 VDD \$3912 VSS OAI21_X1
X$5354 \$3014 \$2921 VSS VDD \$3691 NAND2_X1
X$5355 \$1959 \$2921 VSS VDD \$3725 NAND2_X1
X$5357 \$3065 \$1959 VSS VDD \$3895 OR2_X1
X$5358 \$1855 \$3065 VSS VDD \$3892 NOR2_X1
X$5360 VSS \$3695 \$3723 \$3507 \$3866 \$3694 VDD FA_X1
X$5362 \$3014 \$1578 VSS VDD \$3690 NAND2_X1
X$5364 \$1959 \$1578 VSS VDD \$3814 NAND2_X1
X$5365 \$3814 VSS VDD \$3694 INV_X1
X$5367 \$3874 VSS VDD \$3695 INV_X1
X$5368 \$2921 \$1855 VSS VDD \$3874 NAND2_X1
X$5370 \$1680 \$3065 VSS VDD \$3866 NOR2_X1
X$5373 \$2921 \$1680 VSS VDD \$3697 NAND2_X1
X$5374 \$3697 VSS VDD \$3863 INV_X1
X$5376 \$3817 VSS VDD \$3498 INV_X1
X$5377 \$1581 \$3065 VSS VDD \$3859 NOR2_X1
X$5384 VSS \$3863 \$3452 \$3817 \$3859 \$3818 VDD FA_X1
X$5386 \$3858 VSS VDD \$3818 INV_X1
X$5388 \$1855 \$1578 VSS VDD \$3858 NAND2_X1
X$5391 VSS \$3020 \$I72582 \$3850 \$3822 \$2922 VDD DFFR_X1
X$5396 \$3305 VSS VDD \$3605 CLKBUF_X3
X$5398 VSS \$3605 \$I72996 \$3589 \$3702 \$2922 VDD DFFR_X1
X$5403 VSS \$3824 \$I72835 \$1581 \$3703 \$2922 VDD DFFR_X1
X$5407 VSS \$3824 \$I72282 \$3830 \$4100 \$2922 VDD DFFR_X1
X$5408 \$3456 VSS VDD CLKBUF_X1
X$5410 VSS \$3456 \$I72654 \$3709 \$3830 \$2922 VDD DFFR_X1
X$5432 reset VSS VDD \$5607 CLKBUF_X3
X$5440 VSS \$13388 \$I72939 \$13495 \$13559 \$5607 VDD DFFR_X1
X$5472 \$13543 VSS VDD \$13509 INV_X1
X$5477 \$13533 \$13488 VDD VSS \$13486 XNOR2_X1
X$5479 \$13544 \$13486 VDD VSS \$13515 XNOR2_X1
X$5482 \$13487 VSS VDD \$13545 INV_X1
X$5483 \$13541 \$13548 VDD VSS \$13534 XNOR2_X1
X$5485 \$13546 \$13534 VSS VDD \$13544 XOR2_X1
X$5487 VSS \$13552 \$13548 \$13543 \$13506 \$13545 VDD FA_X1
X$5488 \$13464 \$13555 VDD VSS \$13546 XNOR2_X1
X$5492 VSS \$13491 \$13555 \$13556 \$13536 \$13488 VDD FA_X1
X$5493 \$13556 VSS VDD \$13506 INV_X1
X$5514 \$13464 VSS VDD \$13542 INV_X1
X$5515 VSS \$13418 \$13541 \$13539 \$13542 \$13535 VDD FA_X1
X$5516 \$13539 VSS VDD \$13536 INV_X1
X$5551 xin[6] VSS VDD \$10502 BUF_X1
X$5554 \$10597 \$10595 \$10982 VDD VSS \$10807 HA_X1
X$5555 \$10655 \$10654 \$10755 VDD VSS \$10984 HA_X1
X$5556 \$10444 VSS VDD \$I74142 INV_X2
X$5557 \$7670 VSS VDD \$10444 CLKBUF_X3
X$5561 \$10822 \$10658 \$10757 VDD VSS \$10817 HA_X1
X$5562 \$10661 VSS VDD \$10822 INV_X1
X$5563 \$10757 \$10524 VSS VDD \$10936 NAND2_X1
X$5564 \$10524 \$10757 VSS VDD \$11061 XOR2_X1
X$5565 \$5607 VSS VDD \$10454 BUF_X2
X$5574 VSS \$10444 \$I72534 \$7915 \$10980 \$5607 VDD DFFR_X1
X$5578 \$10445 VSS VDD \$10814 INV_X1
X$5579 \$10807 VSS VDD \$10986 INV_X1
X$5581 \$10815 \$10814 \$10991 VDD VSS \$10756 HA_X1
X$5585 \$10817 VSS VDD \$10935 INV_X1
X$5588 VSS \$10444 \$I72851 \$10686 \$10599 \$10454 VDD DFFR_X1
X$5589 VSS \$10444 \$I72812 \$10599 \$7915 \$10454 VDD DFFR_X1
X$5595 \$10602 \$10693 \$10847 VDD VSS \$11067 HA_X1
X$5599 \$10851 VSS VDD \$10603 INV_X1
X$5603 VSS \$10540 \$I72272 \$10762 \$10683 \$10454 VDD DFFR_X1
X$5604 VSS \$10540 \$I72281 \$10944 \$10414 \$10454 VDD DFFR_X1
X$5608 \$10203 \$8316 VSS VDD \$10945 NAND2_X1
X$5609 \$10946 \$8564 VSS VDD \$10851 NAND2_X1
X$5611 \$10601 \$8316 VSS VDD \$10765 NAND2_X1
X$5613 \$10765 VSS VDD \$10703 INV_X1
X$5614 VSS \$10847 \$10860 \$10606 \$10701 \$10605 VDD FA_X1
X$5616 \$10860 VSS VDD \$10865 INV_X1
X$5619 \$10869 VSS VDD \$10709 INV_X1
X$5623 \$11033 VSS VDD \$10861 INV_X1
X$5626 VSS \$10867 \$10950 \$10869 \$11039 \$10865 VDD FA_X1
X$5631 \$10872 \$10607 \$10205 VSS VDD \$10768 NAND3_X1
X$5632 \$10707 \$10709 \$10872 VDD VSS \$10767 HA_X1
X$5635 VSS \$9716 \$I72963 \$10769 \$10601 \$10360 VDD DFFR_X1
X$5636 VSS \$10608 \$I72687 \$10719 \$10769 \$10208 VDD DFFR_X1
X$5640 \$10767 VSS VDD \$10874 INV_X1
X$5641 \$10874 \$10768 VSS VDD \$10766 NAND2_X1
X$5644 VSS \$10608 \$I72888 \$10888 \$10719 \$10208 VDD DFFR_X1
X$5645 \$6665 VSS VDD \$10608 CLKBUF_X3
X$5649 \$10608 VSS VDD CLKBUF_X1
X$5653 VSS \$10608 \$I72339 \$10362 \$10954 \$10208 VDD DFFR_X1
X$5655 \$11289 VSS VDD \$10361 INV_X1
X$5659 \$10610 VSS VDD \$10581 INV_X1
X$5660 VSS \$10608 \$I73001 \$10615 \$10888 \$10208 VDD DFFR_X1
X$5661 VSS \$9092 \$I72800 \$10614 \$10612 \$10208 VDD DFFR_X1
X$5669 \$11287 \$10895 \$10366 VDD VSS \$10367 HA_X1
X$5674 VSS \$10217 \$I72980 \$10747 \$10772 \$10208 VDD DFFR_X1
X$5675 VSS \$10217 \$I72902 \$10772 \$10961 \$10208 VDD DFFR_X1
X$5681 VSS \$10217 \$I72493 \$10775 \$10964 \$10208 VDD DFFR_X1
X$5682 VSS \$10479 \$I72975 \$6156 \$10775 \$10208 VDD DFFR_X1
X$5684 \$10479 VSS VDD \$I56286 INV_X1
X$5685 \$10339 VSS VDD \$10479 CLKBUF_X3
X$5687 VSS \$10479 \$I72633 \$10562 \$10918 \$10208 VDD DFFR_X1
X$5701 VSS \$10778 \$I72375 \$10927 \$9116 \$10208 VDD DFFR_X1
X$5702 VSS \$10778 \$I72889 \$10779 \$8728 \$10208 VDD DFFR_X1
X$5710 \$10729 VSS VDD \$11015 INV_X1
X$5714 \$10930 \$10921 \$9631 VDD VSS \$9424 HA_X1
X$5715 \$10780 VSS VDD \$10930 INV_X1
X$5716 \$4831 \$9123 VSS VDD \$10780 NAND2_X1
X$5718 \$6156 \$8639 VSS VDD \$10781 NAND2_X1
X$5719 \$10781 VSS VDD \$10715 INV_X1
X$5722 \$4825 \$9123 VSS VDD \$10919 NAND2_X1
X$5725 \$5588 \$8639 VSS VDD \$11007 NAND2_X1
X$5726 \$10783 VSS VDD \$10897 INV_X1
X$5727 \$6138 \$8802 VSS VDD \$10783 NAND2_X1
X$5728 \$10626 VSS VDD \$10785 INV_X1
X$5729 \$6156 \$8931 VSS VDD \$10626 NAND2_X1
X$5732 \$9631 VSS VDD \$11134 INV_X1
X$5735 \$10919 VSS VDD \$10921 INV_X1
X$5738 \$4831 \$8636 VSS VDD \$11011 NAND2_X1
X$5741 VSS \$10785 \$10782 \$11004 \$10897 \$10784 VDD FA_X1
X$5744 \$5588 \$8931 VSS VDD \$10788 NAND2_X1
X$5745 \$10870 \$10631 \$11218 VDD VSS \$10863 HA_X1
X$5746 \$6156 \$8802 VSS VDD \$11001 NAND2_X1
X$5747 \$6138 \$8464 VSS VDD \$11002 NAND2_X1
X$5748 \$10633 VSS VDD \$10870 INV_X1
X$5754 \$10634 VSS VDD \$10849 INV_X1
X$5755 VSS \$10636 \$10789 \$10792 \$10850 \$10637 VDD FA_X1
X$5756 \$10491 VSS VDD \$10850 INV_X1
X$5759 \$4825 \$8639 VSS VDD \$10972 NAND2_X1
X$5761 \$4831 \$8802 VSS VDD \$10833 NAND2_X1
X$5762 \$4825 \$8931 VSS VDD \$10836 NAND2_X1
X$5764 \$4825 \$8802 VSS VDD \$10796 NAND2_X1
X$5766 \$10796 VSS VDD \$10797 INV_X1
X$5768 \$10515 VSS VDD \$10806 INV_X1
X$5772 \$4831 \$8639 VSS VDD \$10999 NAND2_X1
X$5775 \$4831 \$8931 VSS VDD \$10793 NAND2_X1
X$5778 \$10833 VSS VDD \$10794 INV_X1
X$5779 \$10836 VSS VDD \$10990 INV_X1
X$5781 \$4831 \$8464 VSS VDD \$10795 NAND2_X1
X$5782 \$10795 VSS VDD \$10816 INV_X1
X$5783 \$10797 \$10816 \$10650 VDD VSS \$10985 HA_X1
X$5784 \$10806 \$10642 \$10803 VDD VSS \$10979 HA_X1
X$5789 \$10803 \$10498 \$10386 VDD VSS \$10798 HA_X1
X$5811 dxin[0] VSS VDD \$621 BUF_X1
X$5819 \$663 \$623 VSS VDD \$227 NAND2_X1
X$5829 \$477 \$746 \$622 VSS VDD \$623 NAND3_X1
X$5831 \$747 VSS VDD \$359 INV_X1
X$5832 \$664 VSS VDD \$663 INV_X1
X$5833 \$478 \$624 VSS VDD \$664 NAND2_X1
X$5834 \$479 VSS VDD \$478 INV_X1
X$5838 VSS \$545 \$480 \$537 \$291 \$546 VDD FA_X1
X$5841 VSS \$685 \$545 \$786 \$572 \$483 VDD FA_X1
X$5842 \$366 VSS VDD \$482 INV_X1
X$5844 \$484 \$1094 VSS VDD \$366 NOR2_X1
X$5847 \$487 \$484 VSS VDD \$335 OR2_X1
X$5849 \$628 VSS VDD \$569 INV_X1
X$5852 \$748 \$477 VSS VDD \$624 NAND2_X1
X$5854 \$535 VSS VDD \$749 INV_X1
X$5858 \$672 VSS VDD \$751 INV_X1
X$5861 VSS \$675 \$672 \$859 \$360 \$362 VDD FA_X1
X$5865 \$626 VSS VDD \$675 INV_X1
X$5869 VSS \$627 \$685 \$879 \$752 \$692 VDD FA_X1
X$5870 \$628 \$32 VSS VDD \$627 NAND2_X1
X$5871 \$308 \$66 VSS VDD \$692 NAND2_X1
X$5876 VSS \$377 \$484 \$1442 \$597 \$43 VDD DFFR_X1
X$5877 VSS \$377 \$1079 \$257 \$619 \$43 VDD DFFR_X1
X$5878 VSS \$214 \$I72712 \$597 \$610 \$43 VDD DFFR_X1
X$5882 \$491 \$713 VSS VDD \$600 NAND2_X2
X$5883 \$492 \$493 VSS VDD \$491 NAND2_X1
X$5884 \$716 \$495 VSS VDD \$493 NAND2_X1
X$5885 \$495 \$716 \$498 VSS VDD \$713 NAND3_X1
X$5887 \$497 \$725 \$500 VSS VDD \$499 NAND3_X1
X$5888 \$725 \$500 VSS VDD \$381 NAND2_X1
X$5889 \$636 \$731 VSS VDD \$500 NAND2_X1
X$5891 VSS \$34 \$I72913 \$612 \$501 \$43 VDD DFFR_X1
X$5894 VSS \$263 \$I72839 \$380 \$831 \$43 VDD DFFR_X1
X$5898 VSS \$807 \$626 \$809 \$375 \$755 VDD FA_X1
X$5902 \$85 VSS VDD \$377 CLKBUF_X3
X$5907 \$635 VSS VDD \$378 INV_X1
X$5908 \$498 VSS VDD \$492 INV_X1
X$5910 \$635 \$499 \$496 VSS VDD \$716 NAND3_X1
X$5913 \$636 VSS VDD \$730 INV_X1
X$5914 \$730 \$637 \$733 VSS VDD \$725 NAND3_X1
X$5915 \$637 \$733 VSS VDD \$731 NAND2_X1
X$5922 \$584 \$608 \$385 VSS VDD \$498 NAND3_X2
X$5925 VSS \$263 \$I72730 \$310 \$728 \$43 VDD DFFR_X1
X$5929 \$1111 \$724 VSS VDD \$507 NAND2_X2
X$5933 \$814 \$741 \$385 VSS VDD \$740 NAND3_X2
X$5935 \$584 \$385 VSS VDD \$643 NAND2_X1
X$5938 \$298 \$643 \$644 VDD VSS \$734 HA_X1
X$5941 \$734 \$644 \$645 VSS \$389 VDD AOI21_X1
X$5942 \$734 VSS VDD \$802 INV_X1
X$5943 \$645 \$646 VDD VSS \$728 XNOR2_X1
X$5949 VSS \$221 \$I72345 \$647 \$710 \$175 VDD DFFR_X1
X$5951 \$508 \$647 VSS VDD \$398 NOR2_X1
X$5953 \$385 \$394 \$647 VDD VSS \$792 AND3_X1
X$5955 \$385 \$394 \$508 VDD VSS \$547 AND3_X1
X$5962 \$511 \$650 VDD VSS \$710 XNOR2_X1
X$5963 \$648 \$511 VSS VDD \$904 NAND2_X1
X$5964 \$694 \$547 \$530 VDD VSS \$700 HA_X1
X$5966 \$700 VSS VDD \$522 INV_X1
X$5969 VSS \$221 \$I72927 \$405 \$653 \$175 VDD DFFR_X1
X$5972 \$648 VSS VDD \$650 INV_X1
X$5973 \$648 \$530 VSS VDD \$703 NAND2_X1
X$5975 \$522 \$650 \$791 \$703 \$401 VDD VSS \$1045 OAI221_X1
X$5978 VSS \$652 \$I72459 \$694 \$690 \$175 VDD DFFR_X1
X$5980 \$512 VSS VDD \$403 INV_X1
X$5982 \$670 VSS VDD \$656 INV_X1
X$5984 \$513 \$657 \$671 VDD VSS \$670 HA_X1
X$5985 \$514 VSS VDD \$513 INV_X1
X$6003 \$764 \$655 VDD VSS \$690 XNOR2_X1
X$6004 \$654 VSS VDD \$778 INV_X1
X$6006 \$655 \$671 VSS VDD \$654 NAND2_X1
X$6007 VSS \$514 \$764 \$512 \$668 \$773 VDD FA_X1
X$6008 \$657 VSS VDD \$668 INV_X1
X$6037 VSS \$10444 \$I72610 \$10394 \$10502 \$5607 VDD DFFR_X1
X$6049 \$8479 VSS VDD \$10654 INV_X1
X$6052 \$9736 VSS VDD \$10655 INV_X1
X$6055 VSS \$10186 \$10509 \$10445 \$9369 \$10395 VDD FA_X1
X$6058 \$9737 VSS VDD \$10595 INV_X1
X$6059 \$10509 VSS VDD \$10597 INV_X1
X$6061 VSS \$10352 \$10446 \$10447 \$10511 \$10397 VDD FA_X1
X$6063 VSS \$10517 \$10352 \$10520 \$9643 \$10400 VDD FA_X1
X$6067 \$10446 VSS VDD \$10815 INV_X1
X$6071 \$10447 VSS VDD \$10658 INV_X1
X$6074 VSS \$10450 \$10661 \$10670 \$10520 \$10522 VDD FA_X1
X$6075 \$10519 VSS VDD \$10522 INV_X1
X$6079 \$10353 VSS VDD \$10450 INV_X1
X$6085 \$10670 VSS VDD \$10671 INV_X1
X$6088 \$10354 \$10671 \$10451 VDD VSS \$10673 HA_X1
X$6089 \$10673 VSS VDD \$10675 INV_X1
X$6090 \$10451 VSS VDD \$10677 INV_X1
X$6091 \$10677 \$10452 \$10675 VDD \$10524 VSS OAI21_X1
X$6093 \$10452 \$10451 VDD VSS \$10683 XNOR2_X1
X$6095 \$7670 VSS VDD \$I74153 INV_X4
X$6099 \$10454 VSS VDD \$7479 BUF_X2
X$6105 VSS \$10540 \$I72443 \$10453 \$10686 \$10454 VDD DFFR_X1
X$6106 VSS \$10540 \$I72426 \$10601 \$10453 \$10454 VDD DFFR_X1
X$6109 \$10601 \$8201 VSS VDD \$10456 NAND2_X1
X$6110 \$10456 VSS VDD \$10693 INV_X1
X$6111 \$10201 \$8520 VSS VDD \$10459 NAND2_X1
X$6112 \$10459 VSS VDD \$10602 INV_X1
X$6116 \$10203 \$8319 VSS VDD \$10461 NAND2_X1
X$6117 \$10461 VSS VDD \$10699 INV_X1
X$6120 \$10603 \$10699 \$10549 VDD VSS \$10701 HA_X1
X$6122 \$10201 \$8201 VSS VDD \$10463 NAND2_X1
X$6123 \$10463 VSS VDD \$10464 INV_X1
X$6126 \$10554 VSS VDD \$10358 INV_X1
X$6130 \$10464 \$10703 \$10708 VDD VSS \$10605 HA_X1
X$6133 \$10861 \$10606 \$10556 VDD VSS \$10706 HA_X1
X$6135 \$10601 \$8319 VSS VDD \$10554 NAND2_X1
X$6136 \$10706 VSS VDD \$10867 INV_X1
X$6138 \$10465 \$10708 \$10558 VDD VSS \$10710 HA_X1
X$6143 \$10549 \$10558 \$10427 VDD VSS \$10568 HA_X1
X$6147 VSS \$10568 \$10707 \$10607 \$10556 \$10710 VDD FA_X1
X$6149 \$9716 VSS VDD CLKBUF_X1
X$6150 \$6665 VSS VDD \$9716 CLKBUF_X3
X$6153 VSS \$10608 \$I72358 \$10720 \$10467 \$10208 VDD DFFR_X1
X$6154 VSS \$10608 \$I72354 \$10570 \$10720 \$10208 VDD DFFR_X1
X$6155 \$10570 \$10886 \$10112 VDD VSS \$10209 HA_X1
X$6157 \$10362 \$10361 \$10575 VDD VSS \$10725 HA_X1
X$6158 \$10113 \$10575 \$10209 VSS VDD \$10364 NAND3_X1
X$6159 \$10468 \$10581 \$10364 VSS VDD \$10436 NAND3_X1
X$6162 \$10725 \$10113 VSS VDD \$10468 NAND2_X1
X$6165 \$10366 VSS VDD \$10365 INV_X1
X$6166 \$10367 \$10366 \$10436 VSS \$10469 VDD AOI21_X1
X$6167 \$10469 VSS VDD \$10442 INV_X1
X$6168 \$10733 \$11029 \$10115 VDD VSS \$10368 HA_X1
X$6171 VSS \$9092 \$I72847 \$10470 \$10329 \$10208 VDD DFFR_X1
X$6172 VSS \$9092 \$I72869 \$10576 \$10470 \$10208 VDD DFFR_X1
X$6174 VSS \$10079 \$I72856 \$10216 \$10583 \$9773 VDD DFFR_X1
X$6176 \$10208 VSS VDD \$9773 BUF_X1
X$6178 VSS \$10079 \$I72680 \$10574 \$10576 \$9773 VDD DFFR_X1
X$6180 VSS \$10217 \$I72741 \$10572 \$10574 \$10208 VDD DFFR_X1
X$6183 VSS \$10217 \$I72603 \$10374 \$10572 \$9773 VDD DFFR_X1
X$6184 VSS \$10479 \$I72598 \$5588 \$10374 \$9773 VDD DFFR_X1
X$6189 VSS \$10079 \$I72349 \$10583 \$10615 \$9773 VDD DFFR_X1
X$6194 VSS \$10079 \$I72533 \$10746 \$9584 \$9773 VDD DFFR_X1
X$6196 \$10217 VSS VDD \$I55652 INV_X1
X$6197 \$10339 VSS VDD \$10217 CLKBUF_X3
X$6200 \$10339 VSS VDD \$I74144 INV_X4
X$6201 \$1762 VSS VDD \$10339 CLKBUF_X3
X$6202 VSS \$10479 \$I72379 \$4825 \$10747 \$10208 VDD DFFR_X1
X$6207 VSS \$10479 \$I72284 \$11298 \$10121 \$9773 VDD DFFR_X1
X$6212 VSS \$10479 \$I72258 \$6624 \$10734 \$10208 VDD DFFR_X1
X$6214 VSS \$10479 \$10335 \$6138 \$10562 \$10208 VDD DFFR_X1
X$6215 \$10481 \$10410 \$10378 VDD VSS \$10412 HA_X1
X$6219 VSS \$10544 \$10482 \$11014 \$10402 \$10411 VDD FA_X1
X$6222 \$6138 \$8931 VSS VDD \$10484 NAND2_X1
X$6224 \$10484 VSS VDD \$10485 INV_X1
X$6225 \$8636 \$5588 VDD VSS \$10486 AND2_X1
X$6226 VSS \$10487 \$10544 \$10405 \$10531 \$10406 VDD FA_X1
X$6231 \$10731 VSS VDD \$10481 INV_X1
X$6233 VSS \$10482 \$10731 \$10729 \$10538 \$10483 VDD FA_X1
X$6234 \$10730 VSS VDD \$10483 INV_X1
X$6235 VSS \$10546 \$10730 \$10722 \$9631 \$9424 VDD FA_X1
X$6236 \$10722 VSS VDD \$10411 INV_X1
X$6240 VSS \$10715 \$10546 \$10713 \$10485 \$10486 VDD FA_X1
X$6241 \$10713 VSS VDD \$10406 INV_X1
X$6244 \$10528 VSS VDD \$10487 INV_X1
X$6247 VSS \$10526 \$10528 \$10525 \$10523 \$10382 VDD FA_X1
X$6249 \$8798 \$7909 VSS VDD \$10523 NOR2_X1
X$6255 \$10489 VSS VDD \$10631 INV_X1
X$6256 \$6624 \$8152 VSS VDD \$10633 NAND2_X1
X$6259 \$6138 \$8152 VSS VDD \$10491 NAND2_X1
X$6260 \$6624 \$7909 VSS VDD \$10634 NAND2_X1
X$6263 \$6156 \$8464 VSS VDD \$10493 NAND2_X1
X$6264 \$10493 VSS VDD \$10636 INV_X1
X$6266 \$10494 VSS VDD \$10637 INV_X1
X$6268 \$5588 \$8802 VSS VDD \$10494 NAND2_X1
X$6270 \$10682 VSS VDD \$11303 INV_X1
X$6273 \$5588 \$8464 VSS VDD \$10392 NAND2_X1
X$6278 \$10388 VSS VDD \$10508 INV_X1
X$6279 \$6156 \$7909 VSS VDD \$10515 NAND2_X1
X$6281 \$5588 \$8152 VSS VDD \$10497 NAND2_X1
X$6283 \$10512 \$5588 \$7909 VSS VDD \$10514 NAND3_X1
X$6284 \$10514 VSS VDD \$10505 INV_X1
X$6287 \$10385 \$10504 VSS VDD \$10499 NAND2_X1
X$6289 \$10505 \$10386 \$10385 VDD VSS \$10507 HA_X1
X$6290 \$10507 VSS VDD \$10500 INV_X1
X$6292 \$10500 \$10499 VSS VDD \$10645 NAND2_X1
X$6300 \$10497 VSS VDD \$10642 INV_X1
X$6305 \$10651 \$10650 \$10498 VDD VSS \$10643 HA_X1
X$6319 \$11927 \$11901 VDD VSS \$11962 XNOR2_X1
X$6321 \$12195 \$11960 \$11961 VSS \$11958 VDD AOI21_X1
X$6323 \$11645 \$11960 VSS VDD \$11928 NAND2_X1
X$6325 \$11928 \$11765 \$11958 VDD \$11929 VSS OAI21_X1
X$6330 \$11927 VSS VDD \$11968 INV_X1
X$6331 \$12013 \$11901 \$12014 VSS VDD \$11960 NOR3_X1
X$6333 \$11641 VSS VDD \$12313 INV_X1
X$6334 VSS \$10962 \$I72515 \$12219 \$11962 \$11529 VDD DFFR_X1
X$6338 \$11844 \$11766 VSS VDD \$12106 XOR2_X1
X$6345 VSS \$11531 \$I72901 \$11770 \$11947 \$11529 VDD DFFR_X1
X$6347 \$11939 \$11933 VDD VSS \$11947 XNOR2_X1
X$6348 \$11936 \$11933 \$11773 \$11774 \$11795 VDD VSS \$11844 OAI221_X1
X$6349 \$12017 VSS VDD \$11936 INV_X1
X$6351 \$11776 \$11936 \$11937 VSS VDD \$11939 NAND3_X1
X$6368 \$11773 \$12015 VSS VDD \$11767 NAND2_X1
X$6369 \$11772 \$11939 VSS VDD \$12015 NAND2_X1
X$6371 \$11772 VSS VDD \$11933 INV_X1
X$6372 \$10927 \$12200 \$11775 VDD VSS \$12017 HA_X1
X$6396 \$7811 \$8017 VDD VSS \$7808 XNOR2_X1
X$6398 \$7808 \$7879 VDD VSS \$8020 XNOR2_X1
X$6400 VSS \$8065 \$7809 \$8165 \$7887 \$8021 VDD FA_X1
X$6401 \$7810 VSS VDD \$8065 INV_X1
X$6402 \$7813 VSS VDD \$7811 INV_X1
X$6406 \$4312 VSS VDD yout[3] BUF_X1
X$6407 \$7776 \$9003 VDD VSS \$8018 XNOR2_X1
X$6409 \$8018 \$8104 VDD VSS \$8019 XNOR2_X1
X$6410 \$8020 \$8019 VDD VSS \$8074 XNOR2_X1
X$6412 \$8104 VSS VDD \$8021 INV_X1
X$6414 \$7815 VSS VDD \$7814 INV_X1
X$6415 VSS \$8069 \$7810 \$8287 \$7894 \$7813 VDD FA_X1
X$6416 \$7649 \$6466 VSS VDD \$7815 NAND2_X1
X$6418 \$7613 \$6466 VSS VDD \$8170 NAND2_X1
X$6419 VSS \$7820 \$8069 \$8167 \$7898 \$8022 VDD FA_X1
X$6420 \$7649 \$7613 VSS VDD \$7908 XOR2_X1
X$6421 \$7908 \$6786 VSS VDD \$8176 NAND2_X1
X$6427 \$8167 VSS VDD \$8169 INV_X1
X$6431 \$8170 VSS VDD \$8022 INV_X1
X$6434 \$8176 \$8074 VDD VSS \$8344 XNOR2_X1
X$6438 \$8106 VSS VDD \$8076 INV_X1
X$6440 \$7915 \$5129 VSS VDD \$7824 NAND2_X1
X$6442 \$8080 VSS VDD \$7731 INV_X1
X$6445 \$8106 \$5434 VSS VDD \$8080 NAND2_X1
X$6446 \$7915 \$5434 VSS VDD \$8180 NAND2_X1
X$6448 \$8106 \$5674 VSS VDD \$8182 NAND2_X1
X$6449 \$8180 VSS VDD \$8184 INV_X1
X$6456 VSS \$4438 \$I72722 \$4571 \$4570 \$1914 VDD DFFR_X1
X$6457 VSS \$4438 \$I72787 \$4570 \$4690 \$1914 VDD DFFR_X1
X$6458 \$4438 VSS VDD CLKBUF_X1
X$6462 VSS \$4388 \$I72906 \$4536 \$4782 \$1914 VDD DFFR_X1
X$6473 VSS \$4438 \$I72416 \$4690 \$4773 \$1914 VDD DFFR_X1
X$6474 \$4488 VSS VDD \$4438 CLKBUF_X3
X$6479 VSS \$4778 \$I72316 \$5301 \$406 \$1914 VDD DFFR_X1
X$6482 VSS \$4538 \$I72928 \$4595 \$1038 \$2883 VDD DFFR_X1
X$6484 VSS \$4262 \$I72607 \$4643 \$4541 \$2883 VDD DFFR_X1
X$6489 VSS \$4362 \$3243 \$I66124 \$4811 \$3256 VDD DFFR_X1
X$6495 \$4357 \$4709 \$4744 VDD VSS \$4642 HA_X1
X$6498 VSS \$4262 \$4646 \$4716 \$2885 \$4645 VDD DFFR_X1
X$6499 \$4716 \$4648 \$4647 VDD VSS \$4749 HA_X1
X$6501 \$3963 \$4714 \$4809 VDD VSS \$4720 HA_X1
X$6504 VSS \$4362 \$I72572 \$4650 \$4721 \$3256 VDD DFFR_X1
X$6510 VSS \$4848 \$I72876 \$4728 \$4611 \$3256 VDD DFFR_X1
X$6516 VSS \$4848 \$I72410 \$5283 \$4728 \$3256 VDD DFFR_X1
X$6519 VSS \$4452 \$I72417 \$5062 \$4734 \$3256 VDD DFFR_X1
X$6520 VSS \$4452 \$I72372 \$5315 \$2976 \$3256 VDD DFFR_X1
X$6521 VSS \$4452 \$I72650 \$4364 \$4624 \$3256 VDD DFFR_X1
X$6522 \$3965 VSS VDD \$4452 CLKBUF_X3
X$6524 VSS \$4188 \$I72652 \$3760 \$4851 \$3256 VDD DFFR_X1
X$6525 VSS \$4188 \$I72782 \$4658 \$4632 \$4191 VDD DFFR_X1
X$6530 \$4517 VSS VDD CLKBUF_X1
X$6531 \$463 VSS VDD \$4517 CLKBUF_X3
X$6535 VSS \$4517 \$I72302 \$4660 \$4658 \$4191 VDD DFFR_X1
X$6536 VSS \$4517 \$I72256 \$4661 \$4660 \$4191 VDD DFFR_X1
X$6538 VSS \$4517 \$I72877 \$4509 \$4634 \$4191 VDD DFFR_X1
X$6540 VSS \$4316 \$I72992 \$2695 \$4729 \$4191 VDD DFFR_X1
X$6542 VSS \$4276 \$I72852 \$4505 \$4619 \$4191 VDD DFFR_X1
X$6550 VSS \$4276 \$I72838 \$2838 \$4823 \$4191 VDD DFFR_X1
X$6552 VSS \$4119 \$I72999 \$4493 \$4667 \$4191 VDD DFFR_X1
X$6559 VSS \$4276 \$I72531 \$4666 \$4664 \$4191 VDD DFFR_X1
X$6565 VSS \$4119 \$I72295 \$4489 \$4670 \$4191 VDD DFFR_X1
X$6567 VSS \$4119 \$I72627 \$4557 \$4867 \$4460 VDD DFFR_X1
X$6571 VSS \$4097 \$I72676 \$4558 \$4677 \$4460 VDD DFFR_X1
X$6573 VSS \$4371 \$I72702 \$4610 \$4675 \$4460 VDD DFFR_X1
X$6574 VSS \$4371 \$I72936 \$4601 \$4610 \$2922 VDD DFFR_X1
X$6577 \$4279 \$4599 VSS VDD \$4584 NAND2_X1
X$6580 \$4584 VSS VDD \$4579 INV_X1
X$6581 \$4579 \$4580 \$4572 VDD VSS \$4679 HA_X1
X$6592 VSS \$4371 \$I72473 \$4675 \$4759 \$4460 VDD DFFR_X1
X$6597 \$3294 \$4677 VSS VDD \$4676 NAND2_X1
X$6600 \$4100 \$3996 VSS VDD \$4678 NAND2_X1
X$6603 \$4679 VSS VDD \$4686 INV_X1
X$6604 \$4564 VSS VDD \$4765 INV_X1
X$6608 \$4687 VSS VDD \$4684 INV_X1
X$6610 VSS \$4566 \$4680 \$4767 \$4768 \$4684 VDD FA_X1
X$6622 VSS \$2257 \$I72807 \$1303 \$2450 \$175 VDD DFFR_X1
X$6624 \$2414 \$2529 VDD VSS \$2344 XNOR2_X1
X$6627 \$2257 VSS VDD \$I74128 INV_X2
X$6628 \$553 VSS VDD \$2257 CLKBUF_X3
X$6631 \$2587 \$2762 VDD VSS \$2450 XNOR2_X1
X$6636 \$2662 VSS VDD \$2529 INV_X1
X$6637 \$2529 \$2580 \$2663 VDD \$2587 VSS OAI21_X1
X$6640 \$2446 \$2570 \$2443 VDD \$2414 VSS OAI21_X1
X$6641 \$2261 VSS VDD \$2446 INV_X1
X$6642 \$2415 \$2261 \$2444 VSS \$2580 VDD AOI21_X1
X$6643 \$2415 VSS VDD \$2443 INV_X1
X$6646 \$2666 VSS VDD \$2262 INV_X1
X$6649 VSS \$2440 \$2263 \$2264 \$2676 \$2530 VDD FA_X1
X$6652 VSS \$2434 \$2440 \$2298 \$2561 \$2438 VDD FA_X1
X$6655 VSS \$2933 \$2434 \$2287 \$2936 \$2290 VDD FA_X1
X$6659 \$2573 \$2665 \$2261 VDD VSS \$2415 HA_X1
X$6660 \$2578 VSS VDD \$2573 INV_X1
X$6663 \$2568 VSS VDD \$2530 INV_X1
X$6664 VSS \$2532 \$2568 \$2563 \$2531 \$2767 VDD FA_X1
X$6665 \$2563 VSS VDD \$2438 INV_X1
X$6669 \$2531 VSS VDD \$2554 INV_X1
X$6672 VSS \$2554 \$2533 \$2267 \$2551 \$2668 VDD FA_X1
X$6675 \$1855 \$1476 VSS VDD \$2535 NAND2_X1
X$6676 \$2535 VSS VDD \$2543 INV_X1
X$6678 \$2425 VSS VDD \$2266 INV_X1
X$6682 \$2548 VSS VDD \$2551 INV_X1
X$6685 VSS \$2674 \$2548 \$2422 \$2540 \$2543 VDD FA_X1
X$6687 \$2416 VSS VDD \$2278 INV_X1
X$6688 VSS \$2420 \$2425 \$1964 \$2671 \$2422 VDD FA_X1
X$6698 \$2538 VSS VDD \$2540 INV_X1
X$6700 \$1581 \$1467 VSS VDD \$2538 NAND2_X1
X$6717 VSS \$1002 \$I72989 \$1004 \$1025 \$1003 VDD DFFR_X1
X$6718 VSS \$1002 \$I72995 \$1087 \$1004 \$1003 VDD DFFR_X1
X$6725 \$622 \$746 VSS VDD \$1038 XOR2_X1
X$6733 VSS \$1002 \$I72398 \$1432 \$621 \$1003 VDD DFFR_X1
X$6740 VSS \$1002 \$I72396 \$1364 \$1087 \$1003 VDD DFFR_X1
X$6748 \$1132 \$961 \$1224 VDD VSS \$1327 HA_X1
X$6752 \$750 VSS VDD \$1133 INV_X1
X$6753 \$1133 \$1134 VSS VDD \$1378 NAND2_X1
X$6754 \$750 \$1088 \$1227 VSS VDD \$1381 NAND3_X1
X$6755 \$1088 \$1227 VSS VDD \$1134 NAND2_X1
X$6759 \$1139 VSS VDD \$1132 INV_X1
X$6760 VSS \$1142 \$1139 \$1272 \$789 \$1089 VDD FA_X1
X$6762 VSS \$1140 \$1089 \$1275 \$1143 \$1043 VDD FA_X1
X$6764 \$967 VSS VDD \$1088 INV_X1
X$6765 VSS \$1165 \$1142 \$1273 \$823 \$1275 VDD FA_X1
X$6767 \$1044 VSS VDD \$1043 INV_X1
X$6768 VSS \$1151 \$1044 \$1005 \$19 \$864 VDD FA_X1
X$6773 \$1153 \$1277 \$1438 VDD VSS \$1228 HA_X1
X$6774 \$193 \$215 VSS VDD \$1153 NOR2_X1
X$6775 \$193 \$213 VSS VDD \$1151 NOR2_X1
X$6777 \$1054 \$110 \$101 VDD VSS \$967 HA_X1
X$6778 \$1062 VSS VDD \$1093 INV_X1
X$6780 \$1008 \$1098 VSS VDD \$110 NOR2_X1
X$6781 \$1008 \$1230 VSS VDD \$430 NOR2_X1
X$6784 \$109 \$213 VSS VDD \$1277 NOR2_X1
X$6788 \$1079 \$1094 VSS VDD \$1229 NOR2_X1
X$6794 \$1008 \$19 VSS VDD \$1065 NAND2_X1
X$6795 \$1009 \$1008 \$1065 VDD \$1054 VSS OAI21_X1
X$6797 \$484 \$1009 VSS VDD \$804 NOR2_X1
X$6802 VSS \$1231 \$1165 \$1232 \$982 \$1299 VDD FA_X1
X$6803 VSS \$1100 \$1143 \$1299 \$632 \$1444 VDD FA_X1
X$6804 \$1230 \$1079 VSS VDD \$1100 OR2_X1
X$6809 VSS \$1012 \$1411 \$308 \$1184 \$43 VDD DFFR_X1
X$6810 VSS \$377 \$I72985 \$1190 \$308 \$43 VDD DFFR_X1
X$6817 VSS \$1012 \$I72498 \$1528 \$1190 \$43 VDD DFFR_X1
X$6819 VSS \$1012 \$I72320 \$1184 \$1308 \$43 VDD DFFR_X1
X$6820 \$1195 \$1013 VDD VSS \$1014 XNOR2_X1
X$6822 VSS \$994 \$1195 \$1418 \$1201 \$1015 VDD FA_X1
X$6823 \$1013 VSS VDD \$1201 INV_X1
X$6826 \$1102 VSS VDD \$935 INV_X1
X$6827 VSS \$991 \$1015 \$1083 \$935 \$1082 VDD FA_X1
X$6833 \$501 \$467 VSS VDD \$1103 NAND2_X1
X$6834 \$1103 VSS VDD \$1423 INV_X1
X$6837 \$1080 VSS VDD \$1082 INV_X1
X$6839 \$608 \$1078 VSS VDD \$936 NAND2_X1
X$6844 \$817 \$938 VSS VDD \$1105 NAND2_X1
X$6845 \$1105 VSS VDD \$1320 INV_X1
X$6846 VSS \$1017 \$I72340 \$1308 \$1106 \$43 VDD DFFR_X1
X$6848 \$1078 VSS VDD \$1315 INV_X1
X$6852 VSS \$1017 \$I72679 \$1212 \$1073 \$175 VDD DFFR_X1
X$6854 \$1212 \$394 \$385 VSS VDD \$985 NAND3_X1
X$6857 \$1193 \$835 VDD VSS \$1073 XNOR2_X1
X$6859 VSS \$1017 \$I72557 \$1316 \$1203 \$175 VDD DFFR_X1
X$6860 \$1316 \$394 \$385 VSS VDD \$1078 NAND3_X1
X$6861 \$1316 \$1212 VSS VDD \$1209 NOR2_X1
X$6865 \$1209 \$1425 VSS VDD \$1185 NAND2_X1
X$6866 \$1198 \$1021 VDD VSS \$1203 XNOR2_X1
X$6868 \$1110 \$941 \$1198 VSS \$1066 VDD AOI21_X1
X$6869 \$1110 \$941 \$1238 VSS \$1193 VDD AOI21_X1
X$6870 \$1239 \$1021 \$1022 VDD \$942 VSS OAI21_X1
X$6871 \$1110 VSS VDD \$1022 INV_X1
X$6877 \$1303 \$1315 \$941 VDD VSS \$1110 HA_X1
X$6882 \$1186 \$1185 VSS VDD \$1111 NOR2_X1
X$6885 \$1112 \$1182 VSS VDD \$1186 NAND2_X1
X$6890 VSS \$1023 \$I72656 \$1300 \$1304 \$175 VDD DFFR_X1
X$6894 \$947 \$1300 VSS VDD \$1182 NOR2_X1
X$6896 \$385 \$394 \$947 VDD VSS \$1297 AND3_X1
X$6898 \$1045 \$1114 VSS VDD \$968 XOR2_X1
X$6901 \$1042 \$948 VSS VDD \$1116 NAND2_X1
X$6910 \$1242 \$1114 \$1172 VSS \$945 VDD AOI21_X1
X$6911 \$1289 \$1297 \$1114 VDD VSS \$1242 HA_X1
X$6912 \$1023 VSS VDD \$I55821 INV_X1
X$6913 \$553 VSS VDD \$1023 CLKBUF_X3
X$6916 VSS \$1023 \$I72401 \$1289 \$1162 \$175 VDD DFFR_X1
X$6919 \$1116 \$1243 VDD VSS \$1162 XNOR2_X1
X$6920 \$1245 \$1116 VSS VDD \$1246 NAND2_X1
X$6921 \$1117 \$763 \$1024 VSS \$1279 VDD AOI21_X1
X$6922 \$1117 VSS VDD \$1042 INV_X1
X$6925 \$1149 \$1248 \$763 VDD VSS \$1117 HA_X1
X$6928 VSS \$1136 \$1149 \$767 \$1265 \$1264 VDD FA_X1
X$6929 VSS \$1594 \$1264 \$1135 \$1141 \$1261 VDD FA_X1
X$6931 \$1135 \$1251 \$1118 VDD VSS \$1136 HA_X1
X$6932 \$1252 VSS VDD \$1141 INV_X1
X$6934 \$1253 VSS VDD \$1041 INV_X1
X$6937 \$1125 VSS VDD \$958 INV_X1
X$6938 \$1119 VSS VDD \$1039 INV_X1
X$6941 \$1255 VSS VDD \$1037 INV_X1
X$6942 \$1037 \$1130 \$1031 VDD VSS \$956 HA_X1
X$6943 \$1031 \$1030 \$1121 VDD VSS \$1033 HA_X1
X$6944 \$1122 VSS VDD \$955 INV_X1
X$6946 \$1027 VSS VDD \$1026 INV_X1
X$6958 \$1360 \$1254 \$1119 VDD VSS \$1261 HA_X1
X$6962 \$1120 VSS VDD \$1130 INV_X1
X$6965 \$1257 \$1256 \$1260 VDD VSS \$1122 HA_X1
X$6967 \$1588 \$1260 \$1030 VDD VSS \$1125 HA_X1
X$6980 \$6902 \$6783 \$6249 VSS VDD \$6676 NAND3_X1
X$6981 \$6249 \$6901 VDD VSS \$6677 XNOR2_X1
X$6983 VSS \$7065 \$I72612 \$6679 \$6677 \$4645 VDD DFFR_X1
X$6987 \$6403 \$6786 \$6783 VDD VSS \$6675 HA_X1
X$6989 \$6901 \$6968 \$6899 VDD \$7122 VSS OAI21_X1
X$6990 \$6675 VSS VDD \$6899 INV_X1
X$6991 \$6675 \$6902 VSS VDD \$6903 NAND2_X1
X$6992 \$6783 VSS VDD \$6901 INV_X1
X$6993 \$6903 \$6977 \$6676 VSS VDD \$7001 NAND3_X1
X$6994 \$6403 \$6982 \$6902 VDD VSS \$6978 HA_X1
X$6995 \$6978 VSS VDD \$6977 INV_X1
X$6997 \$6994 \$6683 VSS VDD \$6982 NOR2_X1
X$6998 VSS \$6786 \$6683 \$6678 \$6906 VDD AOI21_X4
X$6999 \$6908 \$6682 VSS VDD \$6680 NOR2_X1
X$7000 \$6679 VSS VDD \$6678 INV_X1
X$7001 \$6679 \$6681 \$6908 \$6682 VSS VDD \$6803 NAND4_X1
X$7002 \$6909 \$6803 \$6996 VDD VSS \$6807 HA_X1
X$7004 \$6996 \$6908 VSS VDD \$6994 NOR2_X1
X$7006 \$6996 \$6683 VSS VDD \$4933 NOR2_X2
X$7008 \$6807 \$6683 VSS VDD \$6684 NOR2_X1
X$7010 \$6684 \$6527 VSS VDD \$6911 XOR2_X1
X$7014 \$7001 \$6911 VDD VSS \$7132 XNOR2_X1
X$7017 \$6686 \$6809 \$6685 VDD VSS \$7138 HA_X1
X$7023 \$6689 VSS VDD \$6912 INV_X1
X$7025 VSS \$6913 \$6689 \$7145 \$6690 \$6815 VDD FA_X1
X$7029 VSS \$6489 \$7141 \$7414 \$7017 \$7016 VDD FA_X1
X$7030 VSS \$6913 \$7275 \$6915 \$6690 \$6691 VDD FA_X1
X$7032 VSS \$6692 \$6691 \$6825 \$7020 \$6415 VDD FA_X1
X$7034 \$7021 VSS VDD \$7020 INV_X1
X$7037 \$6825 VSS VDD \$6827 INV_X1
X$7039 VSS \$6166 \$6694 \$7146 \$6234 \$6827 VDD FA_X1
X$7043 VSS \$7025 \$6916 \$7279 \$6690 \$6913 VDD FA_X1
X$7047 VSS \$6697 \$7200 \$7071 \$5896 \$6698 VDD FA_X1
X$7052 \$6690 VSS VDD \$6697 INV_X1
X$7053 VSS \$6837 \$6698 \$6702 \$6699 \$5564 VDD FA_X1
X$7055 \$6701 VSS VDD \$6844 INV_X1
X$7056 \$6702 VSS VDD \$6919 INV_X1
X$7057 \$6844 \$6704 \$6847 VDD VSS \$6705 HA_X1
X$7063 VSS \$6919 \$6918 \$7074 \$7031 \$6705 VDD FA_X1
X$7066 \$6706 \$6266 \$7034 VDD VSS \$7152 HA_X1
X$7070 \$7041 \$6708 \$7037 VDD VSS \$7157 HA_X1
X$7072 \$6707 VSS VDD \$6708 INV_X1
X$7073 \$6543 \$6430 \$7156 VDD VSS \$7043 HA_X1
X$7076 VSS \$7037 \$7206 \$7207 \$7042 \$7049 VDD FA_X1
X$7078 \$6921 VSS VDD \$7048 INV_X1
X$7080 \$6711 VSS VDD \$7046 INV_X1
X$7081 \$5476 \$303 VSS VDD \$6711 NAND2_X1
X$7085 \$6713 VSS VDD \$7163 INV_X1
X$7086 \$6714 VSS VDD \$7166 INV_X1
X$7088 \$6716 VSS VDD \$7053 INV_X1
X$7089 \$6718 VSS VDD \$6719 INV_X1
X$7091 \$6867 \$6720 \$6882 VDD VSS \$7167 HA_X1
X$7092 \$5283 \$5469 \$6874 VDD VSS \$6721 AND3_X1
X$7093 \$6722 \$6882 \$6874 VDD VSS \$7171 HA_X1
X$7094 \$6886 VSS VDD \$6720 INV_X1
X$7100 \$7048 \$7046 \$7050 VDD VSS \$7049 HA_X1
X$7102 \$7050 VSS VDD \$6922 INV_X1
X$7106 \$7053 \$6719 \$7165 VDD VSS \$7295 HA_X1
X$7111 \$4754 \$6436 VSS VDD \$7185 NOR2_X1
X$7114 \$6925 VSS VDD \$7189 INV_X1
X$7115 \$5437 \$5727 VSS VDD \$6925 NAND2_X1
X$7119 \$6725 VSS VDD \$6928 INV_X1
X$7121 \$5579 \$6562 VSS VDD \$6929 NAND2_X1
X$7122 \$6929 VSS VDD \$7178 INV_X1
X$7123 \$5181 \$6732 VSS VDD \$6931 NAND2_X1
X$7124 \$6931 VSS VDD \$6932 INV_X1
X$7126 VSS \$6933 \$7344 \$7753 \$6727 \$7056 VDD FA_X1
X$7127 \$6726 VSS VDD \$6727 INV_X1
X$7130 \$6896 VSS VDD \$6933 INV_X1
X$7131 VSS \$6730 \$6896 \$7608 \$6892 \$6934 VDD FA_X1
X$7136 \$7055 VSS VDD \$6934 INV_X1
X$7139 VSS \$7054 \$7223 \$6935 \$7170 \$6936 VDD FA_X1
X$7140 \$5727 \$6732 VSS VDD \$6733 NAND2_X1
X$7142 \$6733 VSS VDD \$7054 INV_X1
X$7146 \$6439 VSS VDD \$6735 INV_X1
X$7147 VSS \$6849 \$7038 \$6736 \$6574 \$6735 VDD FA_X1
X$7150 \$6740 VSS VDD \$7032 INV_X1
X$7151 VSS \$6834 \$7027 \$6819 \$6739 \$6740 VDD FA_X1
X$7152 VSS \$6814 \$7433 \$6742 \$6820 \$6819 VDD FA_X1
X$7158 \$6937 VSS VDD \$6936 INV_X1
X$7160 \$5579 \$6180 VSS VDD \$6937 NAND2_X1
X$7162 \$4754 \$6180 VSS VDD \$6940 NAND2_X1
X$7164 \$6940 VSS VDD \$7089 INV_X1
X$7171 \$6572 \$6735 \$7235 VDD VSS \$7095 HA_X1
X$7172 \$7038 VSS VDD \$6941 INV_X1
X$7176 \$6736 VSS VDD \$7450 INV_X1
X$7178 \$7035 VSS VDD \$7447 INV_X1
X$7181 \$6737 VSS VDD \$7029 INV_X1
X$7182 VSS \$7032 \$7442 \$7237 \$6942 \$7029 VDD FA_X1
X$7183 \$6739 VSS VDD \$6942 INV_X1
X$7186 VSS \$6943 \$7426 \$7023 \$7026 \$6942 VDD FA_X1
X$7188 \$6818 VSS VDD \$7026 INV_X1
X$7189 \$6812 VSS VDD \$6943 INV_X1
X$7191 \$7023 VSS VDD \$6805 INV_X1
X$7192 VSS \$6745 \$6744 \$6747 \$6743 \$6805 VDD FA_X1
X$7195 VSS \$6341 \$7137 \$7013 \$7015 \$6213 VDD FA_X1
X$7198 \$6949 \$6748 VSS VDD \$7009 NAND2_X1
X$7199 \$6792 \$6753 VSS VDD \$6748 NAND2_X1
X$7201 \$6751 \$6589 \$6750 VSS \$6948 VDD AOI21_X1
X$7202 \$6751 VSS VDD \$6752 INV_X1
X$7203 \$6752 \$6778 VSS VDD \$6753 NAND2_X1
X$7206 VSS \$6449 \$7097 \$7015 \$6747 \$7098 VDD FA_X1
X$7209 \$7013 VSS VDD \$6945 INV_X1
X$7212 \$6792 VSS VDD \$6947 INV_X1
X$7213 \$7103 \$6792 \$6589 \$6750 VSS VDD \$7243 NAND4_X1
X$7214 \$6947 \$6948 \$6949 VDD \$7254 VSS OAI21_X1
X$7215 \$6752 \$6947 \$6949 VDD \$7124 VSS OAI21_X1
X$7216 \$6753 \$6947 VDD VSS \$7249 XNOR2_X1
X$7217 \$6014 \$6589 VDD VSS \$6971 XNOR2_X1
X$7218 \$6014 VSS VDD \$6750 INV_X1
X$7222 \$6452 \$6952 \$6764 \$6759 \$6035 VDD VSS \$7376 OAI221_X1
X$7223 \$6950 \$6191 VSS VDD \$6759 NAND2_X1
X$7232 VSS \$7105 \$I72408 \$6966 \$6971 \$5920 VDD DFFR_X1
X$7233 \$6966 \$6962 \$6950 VDD VSS \$6956 HA_X1
X$7234 \$6950 VSS VDD \$6952 INV_X1
X$7238 \$6956 VSS VDD \$6764 INV_X1
X$7240 \$6298 \$6953 VDD VSS \$6962 AND2_X1
X$7250 dxin[3] VSS VDD \$1631 BUF_X1
X$7253 VSS \$1633 \$I72872 \$1634 \$1542 \$1003 VDD DFFR_X1
X$7256 \$1545 VSS VDD \$1633 CLKBUF_X3
X$7257 \$1002 VSS VDD \$I74132 INV_X2
X$7258 \$1545 VSS VDD \$1002 CLKBUF_X3
X$7266 VSS \$1826 \$I72409 \$1862 \$1631 \$1003 VDD DFFR_X1
X$7271 VSS \$1633 \$I72413 \$1980 \$1634 \$1003 VDD DFFR_X1
X$7273 VSS \$1633 \$I72331 \$1873 \$1700 \$1914 VDD DFFR_X1
X$7279 \$1369 \$1224 VDD VSS \$2119 XNOR2_X1
X$7280 \$1224 \$1548 \$1883 VSS VDD \$1487 NAND3_X1
X$7282 \$1637 \$1711 \$1638 VDD \$622 VSS OAI21_X1
X$7283 \$1709 VSS VDD \$1638 INV_X1
X$7290 \$1224 \$1548 \$1713 \$1925 VSS VDD \$1637 NAND4_X1
X$7293 \$1708 VSS VDD \$1830 INV_X1
X$7294 \$1639 \$1716 \$1713 VDD VSS \$1708 HA_X1
X$7296 \$1720 VSS VDD \$1639 INV_X1
X$7297 \$1500 VSS VDD \$1716 INV_X1
X$7299 VSS \$1722 \$1720 \$1887 \$1602 \$1641 VDD FA_X1
X$7300 VSS \$1890 \$1722 \$1640 \$1603 \$1643 VDD FA_X1
X$7303 \$1504 VSS VDD \$1602 INV_X1
X$7305 \$1610 VSS VDD \$1603 INV_X1
X$7309 \$1726 VSS VDD \$1641 INV_X1
X$7310 \$1724 VSS VDD \$1643 INV_X1
X$7311 VSS \$1438 \$1726 \$1724 \$1892 \$1551 VDD FA_X1
X$7312 \$1737 \$1607 \$2313 VDD VSS \$1551 HA_X1
X$7318 \$211 \$215 VSS VDD \$1644 NOR2_X1
X$7319 \$211 \$213 VSS VDD \$1607 NOR2_X1
X$7323 \$1832 \$213 VSS VDD \$1894 NOR2_X1
X$7326 \$1832 \$487 VSS VDD \$1553 NOR2_X1
X$7327 \$1281 \$1620 \$1610 VDD VSS \$1608 HA_X1
X$7330 \$1833 \$1098 VSS VDD \$1440 NOR2_X1
X$7331 \$1440 \$1650 \$1620 VDD VSS \$1441 HA_X1
X$7332 \$804 \$1840 \$1008 \$1755 VSS VDD \$1227 NAND4_X1
X$7338 \$1833 \$213 VSS VDD \$2236 NOR2_X1
X$7340 \$1093 \$1649 \$213 \$215 VSS VDD \$1903 NOR4_X1
X$7347 \$1649 \$1009 VSS VDD \$1650 NOR2_X1
X$7350 \$1756 \$1840 VSS VDD \$213 NAND2_X1
X$7353 VSS \$1765 \$1446 \$1766 \$1418 \$1554 VDD FA_X1
X$7355 VSS \$1629 \$1765 \$1844 \$1083 \$1628 VDD FA_X1
X$7356 \$1449 VSS VDD \$1628 INV_X1
X$7361 \$1766 VSS VDD \$1843 INV_X1
X$7365 VSS \$1779 \$1629 \$2079 \$1625 \$1450 VDD FA_X1
X$7367 \$1783 \$643 VSS VDD \$1540 NAND2_X1
X$7372 \$1782 VSS VDD \$1779 INV_X1
X$7375 VSS \$1651 \$1782 \$2091 \$1792 \$1786 VDD FA_X1
X$7376 \$1556 VSS VDD \$1651 INV_X1
X$7377 \$817 \$1315 VSS VDD \$2093 NAND2_X1
X$7379 \$831 \$1558 VSS VDD \$1556 NAND2_X1
X$7380 \$1652 \$1558 VSS VDD \$1428 NOR2_X1
X$7384 \$608 VSS VDD \$1652 INV_X1
X$7386 \$1652 \$1655 VSS VDD \$1792 NOR2_X1
X$7389 \$463 VSS VDD \$1017 CLKBUF_X3
X$7393 VSS \$1017 \$I72422 \$1659 \$1803 \$175 VDD DFFR_X1
X$7395 \$385 \$394 \$1529 VDD VSS \$1558 AND3_X1
X$7397 \$385 \$394 \$1659 VDD VSS \$1655 AND3_X1
X$7400 VSS \$6445 \$6580 \$6582 \$6608 \$6447 VDD FA_X1
X$7402 \$4759 \$4677 VSS VDD \$6584 NAND2_X1
X$7403 \$6584 VSS VDD \$6585 INV_X1
X$7404 \$4821 \$4392 VSS VDD \$6586 NAND2_X1
X$7405 \$6586 VSS VDD \$6587 INV_X1
X$7408 \$6580 VSS VDD \$6814 INV_X1
X$7410 \$4821 \$4677 VSS VDD \$6818 NAND2_X1
X$7411 \$4946 \$4392 VSS VDD \$6812 NAND2_X1
X$7413 \$6582 VSS VDD \$6743 INV_X1
X$7416 \$4946 \$3996 VSS VDD \$6583 NAND2_X1
X$7417 \$6583 VSS VDD \$6804 INV_X1
X$7418 VSS \$6587 \$6746 \$6588 \$6585 \$6804 VDD FA_X1
X$7420 \$6588 VSS VDD \$6450 INV_X1
X$7425 \$6796 VSS VDD \$6944 INV_X1
X$7428 \$6463 \$6451 \$6792 VDD VSS \$6787 HA_X1
X$7431 \$6453 VSS VDD \$6452 INV_X1
X$7432 \$6035 \$6191 VDD VSS \$6593 XNOR2_X1
X$7436 \$6787 VSS VDD \$6949 INV_X1
X$7440 \$6589 \$5497 VSS VDD \$6778 NAND2_X1
X$7443 VSS \$5794 \$I72942 \$6454 \$6593 \$5920 VDD DFFR_X1
X$7472 VSS \$9368 \$9736 \$9737 \$8386 \$9800 VDD FA_X1
X$7476 VSS \$9944 \$10143 \$10244 \$9008 \$9010 VDD FA_X1
X$7478 VSS \$9946 \$9944 \$9811 \$9688 \$9739 VDD FA_X1
X$7479 \$9811 VSS VDD \$9742 INV_X1
X$7480 \$8254 \$6466 VSS VDD \$9743 NAND2_X1
X$7482 \$8760 \$6466 VSS VDD \$9945 NAND2_X1
X$7483 \$9945 VSS VDD \$9946 INV_X1
X$7487 \$9008 VSS VDD \$10246 INV_X1
X$7490 \$9948 VSS VDD \$10247 INV_X1
X$7492 \$9743 VSS VDD \$9817 INV_X1
X$7499 \$7915 \$6466 VSS VDD \$9950 NAND2_X1
X$7500 \$9950 VSS VDD \$9999 INV_X1
X$7501 \$8076 \$9997 VSS VDD \$10002 NOR2_X1
X$7502 \$10002 \$9999 \$9838 VDD VSS \$10152 HA_X1
X$7506 VSS \$9838 \$9952 \$9840 \$9744 \$9836 VDD FA_X1
X$7507 \$9952 VSS VDD \$10156 INV_X1
X$7509 \$9835 VSS VDD \$10192 INV_X1
X$7511 VSS \$9842 \$10161 \$10014 \$9843 \$8968 VDD FA_X1
X$7519 \$9043 \$10014 \$10103 VDD VSS \$10015 HA_X1
X$7520 \$10015 VSS VDD \$10274 INV_X1
X$7522 VSS \$8710 \$10033 \$9507 \$7325 \$7479 VDD DFFR_X1
X$7524 \$9507 \$10025 \$9747 VDD VSS \$10028 HA_X1
X$7525 \$9747 \$9857 \$8715 VSS VDD \$9750 NAND3_X1
X$7526 \$9507 \$9751 \$9857 VDD VSS \$9748 HA_X1
X$7527 \$9749 \$10026 \$9750 VSS VDD \$10031 NAND3_X1
X$7530 \$9651 \$9752 VSS VDD \$9653 NOR2_X2
X$7531 \$9653 \$9754 \$9751 VSS VDD NOR2_X4
X$7532 \$9530 \$9955 VDD VSS \$9757 XNOR2_X1
X$7533 \$9757 \$9758 VSS VDD \$9759 NAND2_X1
X$7534 \$9759 VSS VDD \$9754 INV_X4
X$7540 \$9288 VSS VDD CLKBUF_X1
X$7541 \$6665 VSS VDD \$9288 CLKBUF_X3
X$7546 \$9748 \$9747 VSS VDD \$9749 NAND2_X1
X$7547 \$10028 VSS VDD \$10026 INV_X1
X$7549 \$10029 \$10033 VSS VDD \$10035 XOR2_X1
X$7550 \$10031 \$10035 VDD VSS \$10030 XNOR2_X1
X$7552 VSS \$9055 \$9955 \$9752 \$10030 \$7479 VDD DFFR_X1
X$7554 \$9391 VSS VDD \$9753 INV_X1
X$7555 \$9754 \$10043 \$9753 VSS \$10025 VDD AOI21_X1
X$7556 \$9955 \$9392 \$10052 VDD VSS \$10045 HA_X1
X$7557 \$10045 \$9754 VSS VDD \$10029 NOR2_X1
X$7560 \$10052 \$9754 \$9395 VSS VDD NOR2_X4
X$7568 \$6665 VSS VDD \$I74131 INV_X2
X$7569 \$1762 VSS VDD \$6665 CLKBUF_X3
X$7574 \$9960 \$10113 VDD VSS \$10059 XNOR2_X1
X$7576 VSS \$9288 \$I73002 \$4992 \$10059 \$7479 VDD DFFR_X1
X$7577 \$9904 \$9764 VDD VSS \$9901 XNOR2_X1
X$7579 \$9764 VSS VDD \$9766 INV_X1
X$7580 \$9904 VSS VDD \$9909 INV_X1
X$7582 \$9963 VSS VDD \$9658 INV_X1
X$7584 \$9963 \$9764 \$9909 VSS \$9911 VDD AOI21_X1
X$7589 \$6665 VSS VDD \$9092 CLKBUF_X3
X$7590 \$10213 \$10182 \$9764 VDD VSS \$9963 HA_X1
X$7593 \$10069 VSS VDD \$9768 INV_X1
X$7595 \$9768 \$9911 \$9770 VDD \$10070 VSS OAI21_X1
X$7596 \$9964 VSS VDD \$9770 INV_X1
X$7601 \$11184 \$10071 \$10069 VDD VSS \$9964 HA_X1
X$7603 \$10070 \$10116 VDD VSS \$9965 XNOR2_X1
X$7604 \$10169 VSS VDD \$10071 INV_X1
X$7608 VSS \$10079 \$I72391 \$9922 \$9966 \$9773 VDD DFFR_X1
X$7610 VSS \$9771 \$I72753 \$11293 \$9299 \$9773 VDD DFFR_X1
X$7616 VSS \$9771 \$I72611 \$9925 \$9922 \$9773 VDD DFFR_X1
X$7618 VSS \$9771 \$I72636 \$9928 \$9925 \$9773 VDD DFFR_X1
X$7621 VSS \$9771 \$8798 \$4619 \$9928 \$5920 VDD DFFR_X1
X$7622 \$9965 VSS VDD \$9932 INV_X1
X$7623 \$9932 \$10086 VSS \$9972 VDD NAND2_X4
X$7626 \$5997 VSS VDD \$9771 CLKBUF_X3
X$7627 VSS \$9771 \$I72562 \$9969 \$9415 \$9773 VDD DFFR_X1
X$7634 \$9773 VSS VDD \$5920 BUF_X2
X$7641 \$10089 \$9972 VSS \$9971 VDD NAND2_X4
X$7642 \$9965 \$9974 \$9973 VSS VDD \$10089 NAND3_X2
X$7643 \$9775 \$9662 VSS VDD \$9975 NAND2_X1
X$7644 \$9662 \$9775 \$9776 VSS VDD \$9973 NAND3_X2
X$7645 \$9776 VSS VDD \$10075 INV_X2
X$7648 \$9974 \$9973 VSS VDD \$10086 NAND2_X2
X$7649 \$10075 \$9975 VSS \$9974 VDD NAND2_X4
X$7653 \$5269 \$6624 VSS VDD \$10060 XOR2_X1
X$7655 \$9779 \$9780 VSS VDD \$9776 XNOR2_X2
X$7659 \$9781 VSS VDD \$10037 INV_X1
X$7661 \$8636 \$6156 VDD VSS \$9783 AND2_X1
X$7663 \$8798 \$8152 VSS VDD \$10011 NOR2_X1
X$7664 \$5269 \$8464 VSS VDD \$9786 NAND2_X1
X$7665 \$9786 VSS VDD \$9787 INV_X1
X$7671 \$9862 VSS VDD \$9875 INV_X1
X$7672 \$9442 \$9671 \$9875 VDD \$9982 VSS OAI21_X1
X$7673 \$9676 VSS VDD \$9789 INV_X1
X$7674 \$9862 \$9676 VSS VDD \$9790 NAND2_X1
X$7676 \$10060 \$9123 VSS \$9779 VDD NAND2_X4
X$7679 \$9977 VSS VDD \$10164 INV_X1
X$7682 VSS \$9424 \$10126 \$10055 \$9631 \$10159 VDD FA_X1
X$7683 \$10055 VSS VDD \$10155 INV_X1
X$7684 \$6138 \$8639 VSS VDD \$9781 NAND2_X1
X$7685 VSS \$9783 \$10159 \$10023 \$10037 \$9705 VDD FA_X1
X$7686 \$10023 VSS VDD \$10016 INV_X1
X$7687 VSS \$10017 \$10316 \$10402 \$10020 \$10016 VDD FA_X1
X$7689 \$10018 VSS VDD \$10017 INV_X1
X$7690 VSS \$9787 \$10018 \$10008 \$10011 \$10010 VDD FA_X1
X$7694 \$8651 VSS VDD \$7909 INV_X2
X$7698 \$9982 \$9789 VDD VSS \$9984 XNOR2_X1
X$7700 \$9444 \$9849 VDD VSS \$9791 XNOR2_X1
X$7701 \$9824 \$9441 VSS VDD \$9849 XOR2_X1
X$7708 VSS \$9439 \$9985 \$9446 \$9791 \$5920 VDD DFFR_X1
X$7709 \$9801 \$9680 \$9681 VSS \$9824 VDD AOI21_X1
X$7710 \$9810 \$9680 \$9681 VSS \$9848 VDD AOI21_X1
X$7711 \$9794 VSS VDD \$9819 INV_X1
X$7712 \$9794 \$9317 VSS VDD \$9810 NOR2_X1
X$7714 \$9985 \$9684 \$9794 VDD VSS \$9801 HA_X1
X$7722 \$9985 \$9795 VDD \$9680 VSS XOR2_X2
X$7738 \$9452 \$9457 \$9008 VDD VSS \$9010 HA_X1
X$7739 VSS \$9144 \$9061 \$9138 \$9322 \$8759 VDD FA_X1
X$7741 \$9138 VSS VDD \$9141 INV_X1
X$7742 VSS \$9148 \$9272 \$10245 \$8587 \$9141 VDD FA_X1
X$7746 \$9451 VSS VDD \$9452 INV_X1
X$7748 \$9464 VSS VDD \$9322 INV_X1
X$7750 \$9371 VSS VDD \$9457 INV_X1
X$7752 \$7915 \$6786 VSS VDD \$9451 NAND2_X1
X$7753 \$9137 \$6466 VSS VDD \$9464 NAND2_X1
X$7756 \$8957 VSS VDD \$9148 INV_X1
X$7759 \$9064 VSS VDD \$9065 INV_X1
X$7761 \$7613 \$5674 VSS VDD \$9064 NAND2_X1
X$7763 \$7613 \$5129 VSS VDD \$9480 NAND2_X1
X$7766 \$9137 \$5129 VSS VDD \$9172 NAND2_X1
X$7768 \$9168 VSS VDD \$9344 INV_X1
X$7770 \$9172 VSS VDD \$9069 INV_X1
X$7774 \$8959 VSS VDD \$9474 INV_X1
X$7775 \$8106 \$6786 VSS VDD \$9371 NAND2_X1
X$7777 \$9137 \$5674 VSS VDD \$9277 NAND2_X1
X$7778 \$9277 VSS VDD \$9375 INV_X1
X$7781 \$9480 VSS VDD \$9378 INV_X1
X$7785 \$9068 VSS VDD \$9490 INV_X1
X$7786 \$8254 \$5973 VSS VDD \$9278 NAND2_X1
X$7787 \$9278 VSS VDD \$9382 INV_X1
X$7789 \$8760 \$5674 VSS VDD \$9385 NAND2_X1
X$7792 \$8254 \$5674 VSS VDD \$9281 NAND2_X1
X$7793 \$9281 VSS VDD \$9347 INV_X1
X$7794 VSS \$9344 \$9744 \$9071 \$9069 \$9347 VDD FA_X1
X$7795 \$9178 \$9072 \$9174 VDD VSS \$9842 HA_X1
X$7796 \$9173 \$9071 \$9178 VDD VSS \$9282 HA_X1
X$7800 \$9507 \$9192 \$9073 VDD VSS \$9074 HA_X1
X$7803 \$8710 VSS VDD \$I56613 INV_X1
X$7805 \$9351 \$8866 VDD VSS \$9504 XNOR2_X1
X$7806 \$9185 \$9049 \$9351 VSS \$9516 VDD AOI21_X1
X$7807 \$9507 \$9389 \$9049 VDD VSS \$9185 HA_X1
X$7808 \$7670 VSS VDD \$8710 CLKBUF_X3
X$7810 VSS \$8710 \$I72765 \$9194 \$9054 \$7479 VDD DFFR_X1
X$7813 \$9194 VSS VDD \$9079 INV_X1
X$7815 \$9079 \$9080 VSS VDD \$9192 NOR2_X2
X$7818 \$9081 \$9079 \$8262 \$9196 VSS VDD \$9366 NAND4_X1
X$7819 \$9081 \$9080 VSS VDD \$8520 NOR2_X2
X$7823 \$9083 VSS VDD \$9084 INV_X1
X$7830 \$9361 \$9366 VSS VDD \$9394 NOR2_X1
X$7834 \$9084 \$9080 VSS VDD \$8319 NOR2_X2
X$7838 \$9084 \$9285 \$9539 \$9880 VSS VDD \$9361 NAND4_X1
X$7839 \$9211 VSS VDD \$9285 INV_X1
X$7840 \$9285 \$9080 VSS VDD \$8775 NOR2_X1
X$7844 \$9539 \$9080 VSS VDD \$8898 NOR2_X1
X$7848 VSS \$9288 \$I72494 \$9398 \$9047 \$7479 VDD DFFR_X1
X$7849 \$9395 \$9398 VDD VSS \$9287 AND2_X1
X$7850 VSS \$9288 \$I72428 \$9404 \$9290 \$7479 VDD DFFR_X1
X$7851 \$9404 \$9395 VSS VDD \$9091 NAND2_X1
X$7853 \$9090 VSS VDD \$9222 INV_X1
X$7855 \$9091 VSS VDD \$8978 INV_X1
X$7858 VSS \$9092 \$I72805 \$4512 \$9292 \$7479 VDD DFFR_X1
X$7859 VSS \$9092 \$I72841 \$5316 \$10114 \$7479 VDD DFFR_X1
X$7862 \$9237 \$9241 VDD VSS \$9569 XNOR2_X1
X$7865 \$9039 VSS VDD \$9290 INV_X1
X$7866 VSS \$8611 \$I72347 \$9291 \$8032 \$7479 VDD DFFR_X1
X$7869 VSS \$9092 \$I72367 \$4851 \$9901 \$7479 VDD DFFR_X1
X$7871 \$9242 \$9093 \$9568 VDD VSS \$9293 HA_X1
X$7874 \$9250 \$9248 \$9295 VDD VSS \$9094 HA_X1
X$7879 \$9293 VSS VDD \$9294 INV_X1
X$7880 \$9568 VSS VDD \$9572 INV_X1
X$7881 \$9572 \$9575 \$9294 VDD \$9570 VSS OAI21_X1
X$7884 \$9094 \$9295 \$9296 VSS \$9575 VDD AOI21_X1
X$7885 \$9295 VSS VDD \$9408 INV_X1
X$7886 \$9094 VSS VDD \$9583 INV_X1
X$7887 \$9408 \$9343 \$9583 VDD \$9409 VSS OAI21_X1
X$7889 \$9296 \$9408 VDD VSS \$9410 XNOR2_X1
X$7890 \$9096 \$9095 \$9297 VDD VSS \$9097 HA_X1
X$7896 \$9097 \$9297 \$9591 VSS \$9343 VDD AOI21_X1
X$7897 \$9097 VSS VDD \$9342 INV_X1
X$7898 \$9297 VSS VDD \$9589 INV_X1
X$7899 \$9589 \$9302 \$9342 VDD \$9296 VSS OAI21_X1
X$7900 \$9298 VSS VDD \$9591 INV_X1
X$7901 \$9298 \$9297 VDD VSS \$9299 XNOR2_X1
X$7903 \$9098 \$9099 \$9100 VDD VSS \$9301 HA_X1
X$7907 \$9101 \$9261 \$9102 VDD VSS \$9264 HA_X1
X$7908 \$9264 VSS VDD \$9103 INV_X1
X$7912 \$9104 \$9102 VSS VDD \$9304 NAND2_X1
X$7913 \$9102 \$9106 VSS VDD \$9268 NAND2_X1
X$7915 \$9268 VSS VDD \$9269 INV_X1
X$7918 \$9269 \$8787 \$8788 \$9109 VSS VDD \$9335 NAND4_X1
X$7921 \$9301 \$9100 \$9300 VSS \$9298 VDD AOI21_X1
X$7922 \$9301 \$9100 \$9413 VSS \$9302 VDD AOI21_X1
X$7924 \$9413 \$9100 VSS VDD \$9414 XOR2_X1
X$7927 \$9102 VSS VDD \$9598 INV_X1
X$7928 \$9598 \$9303 \$9103 VDD \$9300 VSS OAI21_X1
X$7930 \$9303 \$9102 VDD VSS \$9415 XNOR2_X1
X$7931 \$9104 \$9106 \$9606 VSS \$9303 VDD AOI21_X1
X$7934 \$9304 \$9337 \$9103 \$9335 VSS VDD \$9413 NAND4_X1
X$7936 \$9269 \$9305 VSS VDD \$9337 NAND2_X1
X$7937 \$9107 \$9416 VSS VDD \$9606 NAND2_X1
X$7938 \$8787 \$9614 VSS VDD \$9416 NAND2_X1
X$7939 \$8787 VSS VDD \$9417 INV_X1
X$7940 \$9620 \$9417 \$9107 VDD \$9305 VSS OAI21_X1
X$7941 \$9417 \$9307 \$9107 VDD \$9622 VSS OAI21_X1
X$7943 \$8790 \$8788 \$9109 VSS \$9307 VDD AOI21_X1
X$7944 \$9110 VSS VDD \$9109 INV_X1
X$7945 \$8788 \$9265 VSS VDD \$9627 NAND2_X1
X$7948 \$8790 VSS VDD \$9620 INV_X1
X$7949 \$9620 \$9627 VSS VDD \$9614 NAND2_X1
X$7952 \$9110 \$8788 VDD VSS \$10967 XNOR2_X1
X$7955 \$9111 \$8985 \$8791 VDD \$9265 VSS OAI21_X1
X$7958 \$9111 \$8632 VDD VSS \$9116 XNOR2_X1
X$7959 \$9113 VSS VDD \$9112 INV_X1
X$7961 VSS \$8450 \$9111 \$9118 \$9216 \$9117 VDD FA_X1
X$7965 \$8987 \$9202 VDD VSS \$9208 XNOR2_X1
X$7966 \$9205 \$9208 VDD VSS \$9308 XNOR2_X1
X$7971 VSS \$9332 \$9202 \$9977 \$9641 \$9423 VDD FA_X1
X$7972 \$9119 VSS VDD \$9641 INV_X1
X$7976 \$9122 VSS VDD \$9632 INV_X1
X$7980 VSS \$9329 \$9332 \$9980 \$9632 \$9425 VDD FA_X1
X$7981 VSS \$9590 \$9331 \$9121 \$9705 \$9125 VDD FA_X1
X$7982 \$6138 \$9123 VSS VDD \$9181 NAND2_X1
X$7984 \$1762 VSS VDD \$8705 CLKBUF_X3
X$7985 \$8705 VSS VDD INV_X8
X$7988 \$8798 \$8464 VSS VDD \$9565 NOR2_X1
X$7991 \$9158 VSS VDD \$9127 INV_X1
X$7993 VSS \$9309 \$9329 \$10323 \$9566 \$9567 VDD FA_X1
X$7995 \$9310 VSS VDD \$9309 INV_X1
X$7996 VSS \$9326 \$9310 \$9915 \$9565 \$9127 VDD FA_X1
X$7997 \$5269 \$8802 VSS VDD \$9313 NAND2_X1
X$7998 \$9313 VSS VDD \$9326 INV_X1
X$7999 \$6624 \$8931 VSS VDD \$9158 NAND2_X1
X$8025 \$4488 VSS VDD \$5064 CLKBUF_X3
X$8027 VSS \$5506 \$I72725 \$5200 \$5291 \$1914 VDD DFFR_X1
X$8028 VSS \$5064 \$I72773 \$5232 \$5294 \$4645 VDD DFFR_X1
X$8037 \$5295 VSS VDD \$5298 INV_X1
X$8038 \$4353 \$5434 \$5295 VDD VSS \$5518 HA_X1
X$8039 \$5298 \$5234 \$5236 VDD \$5297 VSS OAI21_X1
X$8042 \$5070 \$5069 \$5303 VSS \$5234 VDD AOI21_X1
X$8044 \$5203 \$5298 \$5236 \$5302 \$5304 VDD VSS \$5436 OAI221_X1
X$8045 \$5295 \$5069 VSS VDD \$5302 NAND2_X1
X$8047 \$5302 \$5202 VSS VDD \$5439 NOR2_X1
X$8048 \$5070 VSS VDD \$5203 INV_X1
X$8050 \$5202 \$5078 \$5304 VDD \$5303 VSS OAI21_X1
X$8051 \$5239 VSS VDD \$5304 INV_X1
X$8053 \$5208 \$5072 VSS VDD \$5202 NAND2_X1
X$8054 \$5069 VSS VDD \$5205 INV_X1
X$8055 \$5072 VSS VDD \$5206 INV_X1
X$8056 \$5205 \$5206 \$5254 VSS VDD \$5136 NOR3_X1
X$8057 \$5075 \$5206 \$5073 VDD \$5239 VSS OAI21_X1
X$8059 \$5207 \$5206 VDD VSS \$5748 XNOR2_X1
X$8060 \$5208 \$4839 VSS VDD \$5254 NAND2_X1
X$8061 \$5208 VSS VDD \$5074 INV_X1
X$8066 \$5303 \$5205 VDD VSS \$5673 XNOR2_X1
X$8068 \$5270 VSS VDD \$5075 INV_X1
X$8071 \$4170 \$5308 \$5208 VDD VSS \$5270 HA_X1
X$8076 VSS \$4538 \$I72628 \$5046 \$5454 \$4645 VDD DFFR_X1
X$8080 VSS \$4937 \$I72647 \$5310 \$4173 \$4645 VDD DFFR_X1
X$8084 VSS \$5378 \$I72798 \$5619 \$169 \$5084 VDD DFFR_X1
X$8089 \$4933 \$5307 VDD VSS \$5308 AND2_X1
X$8096 VSS \$4937 \$I72387 \$5560 \$5310 \$4645 VDD DFFR_X1
X$8097 \$4645 VSS VDD \$5084 BUF_X2
X$8099 VSS \$4937 \$I72386 \$5401 \$3429 \$5084 VDD DFFR_X1
X$8107 VSS \$5378 \$I72385 \$5402 \$5312 \$5084 VDD DFFR_X1
X$8109 VSS \$5378 \$I72381 \$5398 \$4988 \$5084 VDD DFFR_X1
X$8114 VSS \$4957 \$I72383 \$5476 \$1447 \$4657 VDD DFFR_X1
X$8116 \$3685 VSS VDD \$4957 CLKBUF_X3
X$8123 \$4853 VSS VDD CLKBUF_X1
X$8124 \$3685 VSS VDD \$4853 CLKBUF_X3
X$8126 \$5089 VSS VDD CLKBUF_X1
X$8128 VSS \$5089 \$I72794 \$5213 \$5283 \$4657 VDD DFFR_X1
X$8129 VSS \$4857 \$I72672 \$5276 \$5213 \$4657 VDD DFFR_X1
X$8134 \$3685 VSS VDD \$5089 CLKBUF_X3
X$8138 VSS \$4857 \$I72536 \$5579 \$5277 \$4657 VDD DFFR_X1
X$8140 VSS \$4857 \$I72849 \$5385 \$5276 \$4657 VDD DFFR_X1
X$8141 VSS \$4994 \$I72976 \$5267 \$5269 \$4657 VDD DFFR_X1
X$8145 \$4861 VSS VDD CLKBUF_X1
X$8147 \$4657 VSS VDD \$4460 BUF_X2
X$8151 VSS \$4995 \$I73000 \$5172 \$5323 \$4460 VDD DFFR_X1
X$8155 VSS \$5483 \$I72792 \$5243 \$5371 \$4460 VDD DFFR_X1
X$8156 VSS \$4914 \$I72710 \$5216 \$5243 \$4460 VDD DFFR_X1
X$8158 VSS \$5325 \$I72719 \$5327 \$5216 \$4460 VDD DFFR_X1
X$8159 VSS \$4914 \$I72685 \$3294 \$5327 \$4460 VDD DFFR_X1
X$8164 \$4946 \$4279 VSS VDD \$5362 NAND2_X1
X$8166 \$5362 VSS VDD \$5231 INV_X1
X$8167 \$5231 \$5102 \$5356 VDD VSS \$5350 HA_X1
X$8171 VSS \$4994 \$I72446 \$5371 \$5385 \$4657 VDD DFFR_X1
X$8173 \$3685 VSS VDD \$4994 CLKBUF_X3
X$8174 \$4994 VSS VDD CLKBUF_X1
X$8188 \$4822 \$3294 VSS VDD \$5364 NAND2_X1
X$8191 \$5364 VSS VDD \$5415 INV_X1
X$8192 VSS \$5356 \$5431 \$5348 \$5359 \$5123 VDD FA_X1
X$8196 VSS \$5329 \$5418 \$5330 \$5430 \$5348 VDD FA_X1
X$8197 VSS \$5344 \$5917 \$5225 \$5330 \$5226 VDD FA_X1
X$8201 \$4680 VSS VDD \$5223 INV_X1
X$8202 \$5219 \$5225 \$5341 VDD VSS \$5339 HA_X1
X$8203 \$5223 \$5220 \$5331 VDD VSS \$5332 HA_X1
X$8212 \$5339 VSS VDD \$5420 INV_X1
X$8213 \$5341 \$5331 VSS VDD \$5423 NAND2_X1
X$8214 VSS \$4680 \$5419 \$5646 \$5336 \$5334 VDD FA_X1
X$8215 \$5220 VSS VDD \$5336 INV_X1
X$8240 \$8821 VSS VDD \$8476 INV_X1
X$8245 \$8824 VSS VDD \$8478 INV_X1
X$8247 \$8407 \$6674 VSS VDD \$8586 NAND2_X1
X$8250 \$8665 VSS VDD \$8587 INV_X1
X$8254 \$8825 VSS VDD \$8758 INV_X1
X$8257 VSS \$8586 \$8825 \$8408 \$8660 \$8761 VDD FA_X1
X$8258 \$8254 \$6786 VSS VDD \$8660 NAND2_X1
X$8261 \$8667 VSS VDD \$8488 INV_X1
X$8266 VSS \$8589 \$8840 \$8590 \$8588 \$8765 VDD FA_X1
X$8268 \$7615 \$5026 VSS VDD \$8588 NOR2_X1
X$8269 \$8410 VSS VDD \$8765 INV_X1
X$8270 \$8673 VSS VDD \$8589 INV_X1
X$8272 \$7649 \$5129 VSS VDD \$8673 NAND2_X1
X$8275 \$8407 \$5026 VSS VDD \$8591 NAND2_X1
X$8278 VSS \$8680 \$8842 \$8506 \$8591 \$8500 VDD FA_X1
X$8282 \$8760 \$5129 VSS VDD \$8680 NAND2_X1
X$8283 \$8842 VSS VDD \$8846 INV_X1
X$8285 \$8106 \$5973 VSS VDD \$8689 NAND2_X1
X$8288 \$8689 VSS VDD \$8690 INV_X1
X$8291 \$8686 VSS VDD \$8510 INV_X1
X$8293 \$8690 \$8398 \$8399 VDD VSS \$9070 HA_X1
X$8295 \$8700 VSS VDD \$8108 INV_X1
X$8298 \$8417 \$8416 \$8597 VSS \$8596 VDD AOI21_X1
X$8299 \$8417 \$8416 \$8418 VSS \$9051 VDD AOI21_X1
X$8300 \$8597 \$8353 VDD VSS \$8874 XNOR2_X1
X$8301 \$8353 \$8257 \$8768 VSS VDD \$8717 NOR3_X1
X$8307 \$8760 \$5026 VSS VDD \$8686 NAND2_X1
X$8311 \$8856 VSS VDD \$8861 INV_X1
X$8312 VSS \$8415 \$8594 \$8700 \$8595 \$8861 VDD FA_X1
X$8316 \$8420 VSS VDD \$8867 INV_X1
X$8317 VSS \$8710 \$I72438 \$8876 \$8874 \$7479 VDD DFFR_X1
X$8318 VSS \$8710 \$I72439 \$8971 \$8598 \$7479 VDD DFFR_X1
X$8319 \$8878 \$8717 \$8539 VSS \$8599 VDD AOI21_X1
X$8320 \$8718 \$8717 VSS VDD \$8881 NAND2_X1
X$8324 \$8423 \$8424 VSS VDD \$8718 NOR2_X1
X$8326 \$8881 \$8601 \$8599 VDD \$8715 VSS OAI21_X1
X$8329 \$8424 \$8601 \$8425 VDD \$8600 VSS OAI21_X1
X$8334 \$8600 \$8772 VDD VSS \$8771 XNOR2_X1
X$8336 \$8358 VSS VDD \$8772 INV_X1
X$8337 \$8604 \$8430 VSS VDD \$8424 NAND2_X1
X$8338 \$8727 VSS VDD \$8425 INV_X1
X$8339 \$8358 \$8430 \$8428 VSS VDD \$8555 NAND3_X1
X$8340 \$8429 \$8603 \$8774 VSS \$8111 VDD AOI21_X1
X$8341 \$8430 VSS VDD \$8605 INV_X1
X$8342 \$8432 \$8605 \$8431 VDD \$8727 VSS OAI21_X1
X$8343 \$8608 \$8606 \$8432 VDD \$8428 VSS OAI21_X1
X$8345 \$8739 VSS VDD \$8432 INV_X1
X$8347 \$8117 \$8898 \$8604 VDD VSS \$8739 HA_X1
X$8354 \$8772 \$8605 \$8883 VSS VDD \$8603 NOR3_X1
X$8356 \$8604 \$8607 VSS VDD \$8883 NAND2_X1
X$8358 \$8604 VSS VDD \$8606 INV_X1
X$8360 \$8606 \$8773 \$8432 VDD \$8890 VSS OAI21_X1
X$8361 \$8609 VSS VDD \$8608 INV_X1
X$8362 \$8609 \$8607 \$8774 VSS \$8773 VDD AOI21_X1
X$8367 \$8394 \$8775 \$8607 VDD VSS \$8609 HA_X1
X$8368 \$8609 \$8607 \$8741 VSS \$8601 VDD AOI21_X1
X$8373 \$8610 \$8906 VSS VDD \$8741 NAND2_X1
X$8375 VSS \$8611 \$8919 \$8613 \$8745 \$7479 VDD DFFR_X1
X$8377 VSS \$8611 \$I72822 \$8579 \$8750 \$7479 VDD DFFR_X1
X$8379 VSS \$8753 \$8583 \$8616 \$8615 \$8265 VDD FA_X1
X$8380 VSS \$8752 \$8617 \$8618 \$8615 \$8436 VDD FA_X1
X$8382 VSS \$8748 \$9031 \$8939 \$8437 \$8566 VDD FA_X1
X$8385 VSS \$7502 \$8785 \$8742 \$8744 \$8619 VDD FA_X1
X$8386 \$8441 VSS VDD \$8945 INV_X1
X$8388 VSS \$8621 \$8620 \$8623 \$7505 \$8622 VDD FA_X1
X$8391 \$8612 \$8918 \$8780 VDD VSS \$8781 HA_X1
X$8394 \$8611 VSS VDD CLKBUF_X1
X$8395 \$6665 VSS VDD \$8611 CLKBUF_X3
X$8400 \$8618 VSS VDD \$8784 INV_X1
X$8404 \$8939 VSS VDD \$8943 INV_X1
X$8405 \$8438 VSS VDD \$8942 INV_X1
X$8408 \$8439 VSS VDD \$8619 INV_X1
X$8410 VSS \$8620 \$9251 \$9028 \$8742 \$8945 VDD FA_X1
X$8412 \$8443 VSS VDD \$8622 INV_X1
X$8415 \$8560 VSS VDD \$8947 INV_X1
X$8417 VSS \$7344 \$8624 \$8625 \$8127 \$8444 VDD FA_X1
X$8420 VSS \$8628 \$8626 \$8629 \$8736 \$8549 VDD FA_X1
X$8425 VSS \$8737 \$8983 \$9263 \$8625 \$8390 VDD FA_X1
X$8428 \$8626 VSS VDD \$8627 INV_X1
X$8432 \$8629 VSS VDD \$8953 INV_X1
X$8436 VSS \$8631 \$8630 \$8954 \$8445 \$8543 VDD FA_X1
X$8439 \$8630 VSS VDD \$8786 INV_X1
X$8445 \$8954 VSS VDD \$8789 INV_X1
X$8451 \$8951 \$8532 \$8632 VDD VSS \$8792 HA_X1
X$8452 VSS \$8368 \$8951 \$8633 \$8731 \$8448 VDD FA_X1
X$8454 \$8038 \$8530 \$8728 VDD VSS \$8634 HA_X1
X$8456 \$8452 VSS VDD \$8530 INV_X1
X$8463 VSS \$8637 \$8635 \$8795 \$8708 \$8794 VDD FA_X1
X$8464 \$5269 \$8636 VSS VDD \$8637 NAND2_X1
X$8470 \$8935 VSS VDD \$8796 INV_X1
X$8474 VSS \$8638 \$8935 \$9023 \$8934 \$8797 VDD FA_X1
X$8475 \$8455 VSS VDD \$8638 INV_X1
X$8476 \$8636 \$6624 VDD VSS \$8797 AND2_X1
X$8478 \$5269 \$8639 VSS VDD \$8455 NAND2_X1
X$8484 \$6624 \$8639 VSS VDD \$8640 NAND2_X1
X$8485 \$8640 VSS VDD \$8800 INV_X1
X$8488 VSS \$8458 \$I72404 \$8803 \$8704 \$5920 VDD DFFR_X1
X$8489 \$8705 VSS VDD \$8458 CLKBUF_X3
X$8490 \$8458 VSS VDD \$I74134 INV_X2
X$8493 \$8461 \$8802 \$8697 VDD VSS \$8694 HA_X1
X$8496 \$8694 VSS VDD \$8688 INV_X1
X$8497 \$8697 VSS VDD \$8642 INV_X1
X$8498 \$8508 VSS VDD \$8463 INV_X1
X$8499 \$8465 \$8642 \$8688 VDD \$8508 VSS OAI21_X1
X$8504 \$8642 \$8865 \$8688 VDD \$8807 VSS OAI21_X1
X$8508 \$8384 VSS VDD \$8865 INV_X1
X$8509 \$8384 \$8642 VDD VSS \$8848 XNOR2_X1
X$8512 \$6298 \$8681 VDD VSS \$8464 AND2_X1
X$8516 \$8705 VSS VDD \$8644 CLKBUF_X3
X$8518 \$8670 VSS VDD \$8152 INV_X1
X$8520 \$8286 \$8381 VDD VSS \$8817 XNOR2_X1
X$8521 \$8472 \$6298 VSS VDD \$8670 NAND2_X1
X$8524 VSS \$8644 \$I72969 \$8653 \$8473 \$5920 VDD DFFR_X1
X$8527 VSS \$8644 \$I72479 \$8472 \$8817 \$5920 VDD DFFR_X1
X$8531 \$8653 \$6298 VSS VDD \$8651 NAND2_X1
X$8534 \$7379 \$8281 \$8653 \$8472 VDD \$8818 VSS NOR4_X2
X$8559 VSS \$11266 \$I72986 \$11662 \$11781 \$5607 VDD DFFR_X1
X$8571 VSS \$10938 \$I72418 \$11789 \$11787 \$10454 VDD DFFR_X1
X$8575 VSS \$10938 \$I72359 \$11802 \$11790 \$10454 VDD DFFR_X1
X$8576 \$11316 VSS VDD \$I74147 INV_X4
X$8578 \$1762 VSS VDD \$11316 CLKBUF_X3
X$8581 \$11468 \$9389 VSS VDD \$12268 NAND2_X1
X$8584 \$10601 \$9389 VSS VDD \$11814 NAND2_X1
X$8586 \$11565 \$8316 VSS VDD \$11623 NAND2_X1
X$8587 \$11623 VSS VDD \$11827 INV_X1
X$8589 VSS \$11625 \$11817 \$11836 \$11827 \$11693 VDD FA_X1
X$8592 \$11746 \$8564 VSS VDD \$11699 NAND2_X1
X$8595 VSS \$11803 \$I72314 \$11842 \$11620 \$10454 VDD DFFR_X1
X$8597 \$10601 \$9751 VSS VDD \$11951 NAND2_X1
X$8598 \$11809 VSS VDD \$11907 INV_X1
X$8599 VSS \$11809 \$11832 \$11818 \$11814 \$11988 VDD FA_X1
X$8601 \$11818 VSS VDD \$11822 INV_X1
X$8603 VSS \$11822 \$11834 \$11837 \$11817 \$11496 VDD FA_X1
X$8604 \$10203 \$8520 VSS VDD \$11744 NAND2_X1
X$8606 \$11744 VSS VDD \$11693 INV_X1
X$8610 \$11836 \$11964 \$11698 VDD VSS \$11838 HA_X1
X$8611 VSS \$11838 \$11748 \$11627 \$12153 \$11837 VDD FA_X1
X$8612 \$11627 VSS VDD \$11701 INV_X1
X$8615 \$11840 VSS VDD \$11969 INV_X1
X$8618 \$11376 VSS VDD \$I74137 INV_X2
X$8619 \$1762 VSS VDD \$11376 CLKBUF_X3
X$8623 \$11866 \$11628 VSS VDD \$11918 NAND2_X1
X$8631 VSS \$11750 \$I72571 \$11848 \$11565 \$10360 VDD DFFR_X1
X$8634 \$11753 VSS VDD \$12000 INV_X1
X$8635 VSS \$11485 \$11753 \$11850 \$11916 \$11915 VDD FA_X1
X$8640 VSS \$11284 \$I72444 \$11756 \$11848 \$11529 VDD DFFR_X1
X$8641 VSS \$11284 \$I72503 \$11870 \$11756 \$11529 VDD DFFR_X1
X$8642 \$11727 VSS VDD \$11866 INV_X1
X$8648 \$11631 VSS VDD \$11725 INV_X1
X$8654 VSS \$11192 \$11874 \$11383 \$11870 \$11529 VDD DFFR_X1
X$8655 VSS \$11873 \$11872 \$11731 \$11877 \$11739 VDD FA_X1
X$8656 \$11872 VSS VDD \$11982 INV_X1
X$8657 \$10576 \$11417 VSS VDD \$11739 NAND2_X1
X$8658 \$11292 \$11191 VSS VDD \$11873 NAND2_X1
X$8660 \$11874 VSS VDD \$11757 INV_X1
X$8662 \$11757 \$10960 VSS VDD \$11877 NAND2_X1
X$8668 VSS \$6515 \$I72600 \$6768 \$6673 \$5607 VDD DFFR_X1
X$8680 \$4488 VSS VDD \$6515 CLKBUF_X3
X$8684 VSS \$6515 \$I72584 \$6681 \$6773 \$4645 VDD DFFR_X1
X$8685 \$6403 \$6674 \$6517 VDD VSS \$6519 HA_X1
X$8694 VSS \$5506 \$I72720 \$5291 \$5395 \$1914 VDD DFFR_X1
X$8695 VSS \$5064 \$I72714 \$5509 \$5292 \$1914 VDD DFFR_X1
X$8701 VSS \$5506 \$I72509 \$5395 \$5648 \$1914 VDD DFFR_X1
X$8708 VSS \$5506 \$I72435 \$5609 \$5509 \$1914 VDD DFFR_X1
X$8713 \$5460 \$5295 VSS VDD \$5462 NAND2_X1
X$8714 \$5462 \$5134 \$5661 VDD \$5969 VSS OAI21_X1
X$8716 \$6317 \$5396 \$5436 VSS \$5522 VDD AOI21_X1
X$8717 \$5439 \$5396 VSS VDD \$5523 NAND2_X1
X$8718 \$5518 VSS VDD \$5236 INV_X1
X$8719 \$5523 \$5078 \$5522 VDD \$6249 VSS OAI21_X1
X$8723 \$5078 \$5208 VDD VSS \$5683 XNOR2_X1
X$8726 VSS \$4538 \$I72743 \$5454 \$5750 \$4645 VDD DFFR_X1
X$8727 \$5540 VSS VDD \$5464 INV_X1
X$8728 \$5547 \$5453 \$5540 VDD VSS \$5694 HA_X1
X$8729 \$5466 VSS VDD \$5453 INV_X1
X$8734 \$5134 \$5295 VDD VSS \$5610 XNOR2_X1
X$8737 VSS \$5612 \$I72370 \$5611 \$5673 \$4645 VDD DFFR_X1
X$8741 VSS \$5612 \$I72300 \$5307 \$5683 \$4645 VDD DFFR_X1
X$8746 \$5464 \$5694 VDD VSS \$5614 XNOR2_X1
X$8747 \$5691 VSS VDD \$5615 INV_X1
X$8748 VSS \$5545 \$5691 \$5833 \$5696 \$5453 VDD FA_X1
X$8749 VSS \$5555 \$5689 \$5835 \$5466 \$5468 VDD FA_X1
X$8751 \$5549 VSS VDD \$5545 INV_X1
X$8752 \$5398 \$5467 \$5468 VDD \$5547 VSS OAI21_X1
X$8753 \$5398 \$5399 VSS VDD \$5468 NAND2_X1
X$8754 \$5473 \$5399 VSS VDD \$5549 NAND2_X1
X$8755 \$5398 \$5619 VSS VDD \$5466 NAND2_X1
X$8758 \$5190 \$5467 VSS VDD \$5696 NOR2_X1
X$8759 \$5467 \$5473 VSS VDD \$5555 OR2_X1
X$8762 VSS \$4937 \$I72916 \$5469 \$5560 \$5084 VDD DFFR_X1
X$8765 VSS \$5378 \$5564 \$5569 \$5401 \$5084 VDD DFFR_X1
X$8773 \$5190 \$5469 VSS VDD \$5767 NAND2_X1
X$8774 \$4752 \$5315 VSS VDD \$5471 NAND2_X1
X$8775 \$5471 VSS VDD \$5618 INV_X1
X$8776 \$5569 VSS VDD \$5467 INV_X1
X$8778 \$5378 VSS VDD \$I56037 INV_X1
X$8780 \$3965 VSS VDD \$5378 CLKBUF_X3
X$8781 VSS \$5378 \$I72921 \$5473 \$5402 \$5084 VDD DFFR_X1
X$8786 VSS \$5378 \$I72311 \$5587 \$5569 \$5084 VDD DFFR_X1
X$8787 VSS \$5620 \$I72735 \$5594 \$5405 \$5084 VDD DFFR_X1
X$8788 VSS \$5378 \$I72802 \$5405 \$5399 \$5084 VDD DFFR_X1
X$8791 VSS \$4853 \$I72938 \$5437 \$5594 \$4657 VDD DFFR_X1
X$8794 VSS \$4853 \$I72726 \$5480 \$5479 \$4657 VDD DFFR_X1
X$8804 VSS \$4853 \$I72393 \$5479 \$5476 \$4657 VDD DFFR_X1
X$8808 VSS \$5089 \$I72573 \$5736 \$5480 \$4657 VDD DFFR_X1
X$8809 VSS \$5089 \$I72466 \$5727 \$5736 \$4657 VDD DFFR_X1
X$8811 VSS \$5596 \$I72541 \$5732 \$5587 \$4657 VDD DFFR_X1
X$8813 VSS \$4994 \$I72690 \$5382 \$5588 \$4657 VDD DFFR_X1
X$8818 VSS \$4994 \$I72608 \$5482 \$5437 \$4657 VDD DFFR_X1
X$8819 VSS \$4994 \$I72642 \$5583 \$5482 \$4657 VDD DFFR_X1
X$8820 VSS \$5779 \$I72717 \$4822 \$5583 \$4657 VDD DFFR_X1
X$8821 VSS \$4861 \$I72643 \$5323 \$5579 \$4460 VDD DFFR_X1
X$8833 VSS \$5483 \$I72586 \$5723 \$5727 \$4460 VDD DFFR_X1
X$8837 VSS \$5483 \$I72366 \$5563 \$5723 \$4460 VDD DFFR_X1
X$8839 VSS \$5483 \$I72759 \$5561 \$5563 \$4460 VDD DFFR_X1
X$8841 VSS \$5325 \$I72674 \$4599 \$5561 \$4460 VDD DFFR_X1
X$8845 \$4865 \$4280 VSS VDD \$5542 NAND2_X1
X$8847 \$5542 VSS VDD \$5541 INV_X1
X$8848 \$5541 \$5415 \$5429 VDD VSS \$5537 HA_X1
X$8851 \$4100 \$4677 VSS VDD \$5494 NAND2_X1
X$8852 \$5494 VSS VDD \$5495 INV_X1
X$8853 \$4599 \$4392 VSS VDD \$5496 NAND2_X1
X$8854 \$5496 VSS VDD \$5521 INV_X1
X$8855 \$5431 VSS VDD \$5515 INV_X1
X$8857 \$5513 \$5429 \$5430 VDD VSS \$5798 HA_X1
X$8860 VSS \$5483 \$5692 \$4868 \$5711 \$4460 VDD DFFR_X1
X$8861 \$4868 VSS VDD \$5635 INV_X1
X$8863 \$5707 VSS VDD \$5325 CLKBUF_X3
X$8868 \$3294 \$5635 VSS VDD \$5828 NOR2_X1
X$8869 \$4865 \$4100 VSS VDD \$5487 NAND2_X1
X$8871 \$5487 VSS VDD \$5637 INV_X1
X$8872 \$5679 VSS VDD \$5825 INV_X1
X$8873 \$4822 \$4280 VSS VDD \$5679 NAND2_X1
X$8874 \$4280 \$5635 VSS VDD \$6351 NOR2_X1
X$8877 \$4599 \$4677 VSS VDD \$5492 NAND2_X1
X$8878 \$5492 VSS VDD \$5638 INV_X1
X$8879 VSS \$5537 \$5806 \$5653 \$5672 \$5664 VDD FA_X1
X$8881 \$4759 \$3996 VSS VDD \$5493 NAND2_X1
X$8882 \$5493 VSS VDD \$5657 INV_X1
X$8883 VSS \$5521 \$5793 \$5513 \$5495 \$5657 VDD FA_X1
X$8884 \$5418 VSS VDD \$6010 INV_X1
X$8887 \$5341 VSS VDD \$5422 INV_X1
X$8888 \$5419 \$5422 \$5420 VDD \$5497 VSS OAI21_X1
X$8889 \$5501 \$5422 \$5420 VDD \$5499 VSS OAI21_X1
X$8890 \$5423 VSS VDD \$5503 INV_X1
X$8891 \$5499 \$5503 \$5008 VSS \$6014 VDD AOI21_X1
X$8892 \$5008 VSS VDD \$5334 INV_X1
X$8893 \$5332 VSS VDD \$5501 INV_X1
X$8900 \$5419 \$5341 VDD VSS \$5498 XNOR2_X1
X$8903 \$5646 VSS VDD \$5642 INV_X1
X$8922 \$1826 VSS VDD CLKBUF_X1
X$8923 VSS \$1826 \$I72815 \$2223 \$2117 \$1003 VDD DFFR_X1
X$8927 VSS \$2274 \$I72819 \$2225 \$2163 \$1003 VDD DFFR_X1
X$8936 VSS \$1826 \$I72378 \$2418 \$2223 \$1003 VDD DFFR_X1
X$8940 VSS \$2274 \$I72250 \$2427 \$2225 \$1003 VDD DFFR_X1
X$8943 \$1916 VSS VDD CLKBUF_X1
X$8944 \$1545 VSS VDD \$1916 CLKBUF_X3
X$8948 VSS \$1916 \$I72434 \$2498 \$2228 \$1914 VDD DFFR_X1
X$8950 \$2120 \$1921 VDD VSS \$2301 XNOR2_X1
X$8953 \$1923 \$2307 VSS VDD \$2120 NAND2_X1
X$8958 \$1925 \$2122 VSS VDD \$2307 NAND2_X1
X$8961 VSS \$2315 \$2007 \$2230 \$2187 \$2123 VDD FA_X1
X$8965 \$1640 VSS VDD \$2187 INV_X1
X$8969 \$2311 VSS VDD \$2398 INV_X1
X$8970 VSS \$2313 \$2123 \$2316 \$2198 \$2195 VDD FA_X1
X$8971 \$2316 \$2124 \$2185 VDD VSS \$2315 HA_X1
X$8976 VSS \$2232 \$2311 \$2231 \$2322 \$2320 VDD FA_X1
X$8977 \$2125 VSS VDD \$2232 INV_X1
X$8978 \$2318 VSS VDD \$2320 INV_X1
X$8980 \$2323 VSS VDD \$2322 INV_X1
X$8982 VSS \$1835 \$2198 \$2470 \$2035 \$2128 VDD FA_X1
X$8983 \$2326 \$1894 \$2233 VDD VSS \$2318 HA_X1
X$8984 \$2130 VSS VDD \$1094 INV_X1
X$8986 \$2402 VSS VDD \$1933 INV_X1
X$8990 VSS \$1934 \$I72740 \$2896 \$168 \$1445 VDD DFFR_X1
X$8992 \$2199 \$2127 \$2639 VDD VSS \$2323 HA_X1
X$8996 \$2238 \$2341 VSS VDD \$1098 NAND2_X1
X$8997 \$2336 \$2480 VSS VDD \$1009 NAND2_X1
X$9002 \$1934 VSS VDD CLKBUF_X1
X$9004 VSS \$1934 \$I72750 \$2046 \$2217 \$1445 VDD DFFR_X1
X$9006 VSS \$2242 \$I72637 \$2217 \$2245 \$1445 VDD DFFR_X1
X$9020 xin[0] VSS VDD \$12899 BUF_X1
X$9022 VSS \$12345 \$I72823 \$7613 \$12999 \$5607 VDD DFFR_X1
X$9037 VSS \$12345 \$I72526 \$13153 \$12772 \$5607 VDD DFFR_X1
X$9041 VSS \$12724 \$I72478 \$13113 \$13105 \$5607 VDD DFFR_X1
X$9044 \$12411 VSS VDD \$13168 INV_X1
X$9046 \$12950 \$11986 VSS VDD \$13130 OR2_X1
X$9048 \$11986 \$12950 VSS VDD \$13108 NAND2_X1
X$9049 VSS \$13001 \$13033 \$13291 \$13036 \$13000 VDD FA_X1
X$9051 VSS \$12489 \$13001 \$13170 \$12779 \$13040 VDD FA_X1
X$9052 \$13041 VSS VDD \$13040 INV_X1
X$9055 VSS \$12780 \$13080 \$13045 \$13002 \$13081 VDD FA_X1
X$9059 \$13108 \$13130 VSS VDD \$13193 NAND2_X1
X$9062 \$12952 VSS VDD \$13161 INV_X1
X$9065 \$13111 VSS VDD \$13081 INV_X1
X$9068 \$13082 VSS VDD \$13202 INV_X1
X$9069 VSS \$12782 \$13082 \$13046 \$13045 \$12992 VDD FA_X1
X$9073 \$13046 VSS VDD \$13003 INV_X1
X$9076 \$13048 VSS VDD \$13047 INV_X1
X$9077 \$13004 \$13003 \$13006 VDD VSS \$13048 HA_X1
X$9078 \$13047 \$13005 VSS VDD \$13131 NAND2_X1
X$9079 \$13006 \$13050 VSS VDD \$13005 NAND2_X1
X$9080 \$13006 VSS VDD \$13052 INV_X1
X$9081 \$13050 \$13052 VDD VSS \$13007 XNOR2_X1
X$9082 \$13026 \$13007 \$13008 VDD VSS \$13009 HA_X1
X$9083 \$13009 \$13008 \$12922 VSS \$13083 VDD AOI21_X1
X$9084 \$13009 \$13008 \$12692 VSS \$13216 VDD AOI21_X1
X$9093 \$12692 \$13008 VSS VDD \$13010 XOR2_X1
X$9095 VSS \$12753 \$I72646 \$13070 \$13010 \$10360 VDD DFFR_X1
X$9098 VSS \$12753 \$I72751 \$13073 \$13070 \$10360 VDD DFFR_X1
X$9102 VSS \$12753 \$I72574 \$13085 \$12953 \$10360 VDD DFFR_X1
X$9103 VSS \$12753 \$I72323 \$13086 \$13085 \$10360 VDD DFFR_X1
X$9104 VSS \$12753 \$I72341 \$11295 \$13086 \$10360 VDD DFFR_X1
X$9106 \$12957 \$13087 VDD VSS \$13075 XNOR2_X1
X$9107 \$13073 \$13076 \$12790 VDD VSS \$13012 HA_X1
X$9112 \$12957 VSS VDD \$13135 INV_X1
X$9113 \$13087 VSS VDD \$13122 INV_X1
X$9115 \$13122 \$12882 \$13136 VDD \$13123 VSS OAI21_X1
X$9118 \$13123 \$13134 VDD VSS \$11286 XNOR2_X1
X$9120 \$12792 \$13088 VDD VSS \$13076 XNOR2_X1
X$9124 \$13013 VSS VDD \$13090 INV_X1
X$9128 \$12604 \$10576 VDD VSS \$13014 AND2_X1
X$9129 \$13142 VSS VDD \$13120 INV_X1
X$9131 \$13094 VSS VDD \$13065 INV_X1
X$9136 \$13089 VSS VDD \$13088 INV_X1
X$9137 \$13089 \$12792 VSS VDD \$13137 NAND2_X1
X$9138 \$13090 \$13138 \$13089 VDD VSS \$13139 HA_X1
X$9142 VSS \$13069 \$13140 \$13125 \$13109 \$13092 VDD FA_X1
X$9143 \$13093 VSS VDD \$13092 INV_X1
X$9146 VSS \$13120 \$13162 \$13094 \$13119 \$13014 VDD FA_X1
X$9147 \$13143 VSS VDD \$13119 INV_X1
X$9148 \$11383 \$12006 VSS VDD \$13143 NAND2_X1
X$9151 \$11757 \$12604 VSS VDD \$13240 NAND2_X1
X$9152 VSS \$13096 \$13160 \$13109 \$13107 \$13156 VDD FA_X1
X$9153 \$12977 VSS VDD \$13096 INV_X1
X$9159 \$11295 \$11635 VSS VDD \$13039 NAND2_X1
X$9160 \$13039 VSS VDD \$13030 INV_X1
X$9165 \$13097 VSS VDD \$13145 INV_X1
X$9166 \$13025 VSS VDD \$13107 INV_X1
X$9170 \$13021 VSS VDD \$13024 INV_X1
X$9171 VSS \$13016 \$13097 \$13025 \$13029 \$13024 VDD FA_X1
X$9173 \$11295 \$12006 VSS VDD \$13021 NAND2_X1
X$9193 \$12607 \$11635 VSS VDD \$13286 NOR2_X1
X$9195 \$13102 VSS VDD \$13149 INV_X1
X$9196 \$11295 \$12290 VSS VDD \$13102 NAND2_X1
X$9550 VSS \$35 \$61 \$42 \$80 \$54 VDD FA_X1
X$9554 \$56 VSS VDD \$35 INV_X1
X$9556 \$36 VSS VDD \$54 INV_X1
X$9557 VSS \$38 \$36 \$31 \$63 \$30 VDD FA_X1
X$9563 \$58 VSS VDD \$38 INV_X1
X$9568 VSS \$67 \$I72490 \$68 \$32 \$43 VDD DFFR_X1
X$9575 \$39 \$27 VSS VDD \$10 NOR2_X1
X$9580 \$10 VSS VDD \$215 INV_X1
X$9583 \$43 \$28 VSS VDD \$27 NAND2_X1
X$9585 VSS \$214 \$I72524 \$21 \$10 \$43 VDD DFFR_X1
X$9587 VSS \$34 \$I72542 \$47 \$21 \$43 VDD DFFR_X1
X$9661 xin[3] VSS VDD \$13559 BUF_X1
X$10273 VSS \$11489 \$I72648 \$12527 \$11061 \$10454 VDD DFFR_X1
X$10283 VSS \$12345 \$I72507 \$12404 \$11270 \$10454 VDD DFFR_X1
X$10286 VSS \$11803 \$I72590 \$12411 \$12404 \$10454 VDD DFFR_X1
X$10288 VSS \$12416 \$12347 \$12532 \$12414 \$12349 VDD FA_X1
X$10289 \$12261 VSS VDD \$12348 INV_X1
X$10292 \$11746 \$9751 VSS VDD \$12349 NAND2_X1
X$10297 \$11802 \$9389 VSS VDD \$12416 NAND2_X1
X$10299 \$9192 \$11988 VSS VDD \$12414 OR2_X1
X$10301 \$11746 \$9192 VSS VDD \$12350 NAND2_X1
X$10303 \$12350 VSS VDD \$12267 INV_X1
X$10310 \$11565 \$9751 VSS VDD \$12351 NAND2_X1
X$10312 \$12427 VSS VDD \$12541 INV_X1
X$10314 \$10203 \$9751 VSS VDD \$12429 NAND2_X1
X$10315 \$12269 VSS VDD \$12542 INV_X1
X$10318 \$11565 \$9192 VSS VDD \$12638 NAND2_X1
X$10319 \$9389 \$10946 VDD VSS \$12356 AND2_X1
X$10322 \$9389 \$10203 VDD VSS \$12548 AND2_X1
X$10323 \$12442 VSS VDD \$12357 INV_X1
X$10324 \$10946 \$9192 VSS VDD \$12358 NAND2_X1
X$10327 \$12447 VSS VDD \$12492 INV_X1
X$10330 \$12494 VSS VDD \$12553 INV_X1
X$10331 \$12270 VSS VDD \$12647 INV_X1
X$10333 \$12360 VSS VDD \$12495 INV_X1
X$10337 \$12449 VSS VDD \$12653 INV_X1
X$10338 \$11834 VSS VDD \$12362 INV_X1
X$10339 \$11583 VSS VDD \$I74119 INV_X2
X$10342 \$11748 VSS VDD \$12558 INV_X1
X$10344 \$12271 VSS VDD \$12272 INV_X1
X$10346 \$12273 \$12272 \$12337 VDD VSS \$12455 HA_X1
X$10348 \$12276 VSS VDD \$12367 INV_X1
X$10349 \$12181 \$12367 \$12179 VSS VDD \$12368 NAND3_X1
X$10351 VSS \$11583 \$I72673 \$12341 \$12277 \$10360 VDD DFFR_X1
X$10352 VSS \$11750 \$I72763 \$12466 \$12341 \$10360 VDD DFFR_X1
X$10354 \$12466 \$12335 \$12001 VDD VSS \$12339 HA_X1
X$10355 \$12183 \$12372 VDD VSS \$12373 XNOR2_X1
X$10359 \$12076 \$12375 VDD VSS \$12335 XNOR2_X1
X$10362 \$12485 VSS VDD \$12484 INV_X1
X$10367 \$12479 VSS VDD \$12333 INV_X1
X$10370 \$10959 \$12290 VSS VDD \$12282 NAND2_X1
X$10372 \$12470 \$12450 \$12246 VDD VSS \$12473 HA_X1
X$10375 \$12337 VSS VDD \$12454 INV_X1
X$10377 \$12454 \$11587 \$12366 VDD \$12364 VSS OAI21_X1
X$10378 \$12455 VSS VDD \$12366 INV_X1
X$10384 VSS \$11750 \$I72309 \$12474 \$11987 \$10360 VDD DFFR_X1
X$10388 \$12372 \$12278 \$12465 VSS \$12581 VDD AOI21_X1
X$10390 VSS \$12184 \$I72342 \$12504 \$12474 \$10360 VDD DFFR_X1
X$10394 \$12375 VSS VDD \$12483 INV_X1
X$10395 \$12483 \$12076 \$12486 VDD \$12376 VSS OAI21_X1
X$10396 \$12484 \$12585 \$12375 VDD VSS \$12482 HA_X1
X$10397 \$12482 VSS VDD \$12486 INV_X1
X$10400 VSS \$12473 \$12572 \$12479 \$12551 \$12481 VDD FA_X1
X$10402 VSS \$12462 \$12560 \$12470 \$12564 \$12377 VDD FA_X1
X$10403 \$12458 VSS VDD \$12377 INV_X1
X$10407 \$11295 \$11191 VSS VDD \$12382 NAND2_X1
X$10409 \$12382 VSS VDD \$12383 INV_X1
X$10414 \$12288 VSS VDD \$12291 INV_X1
X$10416 \$12423 \$12214 VSS VDD \$12290 NOR2_X2
X$10417 \$12291 \$12214 VSS VDD \$12006 NOR2_X2
X$10419 \$12291 \$12423 \$12313 \$12312 VSS VDD \$12301 NAND4_X1
X$10421 VSS \$12391 \$I72981 \$12294 \$12196 \$11529 VDD DFFR_X1
X$10423 \$11450 \$12294 VDD VSS \$11191 AND2_X1
X$10425 \$10576 \$12006 VSS VDD \$12458 NAND2_X1
X$10426 \$12380 VSS VDD \$12462 INV_X1
X$10427 \$11292 \$11635 VSS VDD \$12380 NAND2_X1
X$10428 \$12383 \$12448 \$12450 VDD VSS \$12384 HA_X1
X$10429 \$12385 VSS VDD \$12448 INV_X1
X$10431 \$10117 \$10960 VSS VDD \$12385 NAND2_X1
X$10435 VSS \$11192 \$I72552 \$12432 \$12547 \$11529 VDD DFFR_X1
X$10436 \$12194 VSS VDD \$12536 INV_X1
X$10438 \$12432 VSS VDD \$12423 INV_X1
X$10440 \$12394 \$12214 \$12611 VSS VDD NOR2_X4
X$10445 \$11450 VSS VDD \$12214 INV_X4
X$10446 \$12294 \$12199 \$12301 VSS VDD \$12402 NOR3_X1
X$10451 \$12296 \$12304 \$12392 \$12403 VSS VDD \$12398 NAND4_X1
X$10452 \$12401 \$12392 \$12403 VSS VDD \$12393 NAND3_X1
X$10454 \$11823 \$12394 \$12402 VSS VDD \$12395 NAND3_X1
X$10470 \$12394 VSS VDD \$12401 INV_X1
X$10471 \$12524 \$12398 \$12395 VDD VSS \$12525 OAI21_X2
X$10498 xin[7] VSS VDD \$11781 BUF_X1
X$10502 \$11316 VSS VDD \$11489 CLKBUF_X3
X$10521 VSS \$10938 \$I72356 \$12027 \$11789 \$10454 VDD DFFR_X1
X$10522 VSS \$11803 \$11988 \$11987 \$12027 \$10454 VDD DFFR_X1
X$10523 \$12029 VSS VDD \$11986 INV_X1
X$10526 \$11987 \$9745 VSS VDD \$12029 NAND2_X1
X$10529 \$11953 \$11907 \$12491 VDD VSS \$11908 HA_X1
X$10530 \$11951 VSS VDD \$11953 INV_X1
X$10535 \$11988 \$8316 VSS VDD \$12233 NOR2_X1
X$10539 \$11802 \$8316 VSS VDD \$11991 NAND2_X1
X$10540 \$11991 VSS VDD \$11992 INV_X1
X$10542 \$11988 \$8319 VSS VDD \$12141 NOR2_X1
X$10546 \$11988 \$8564 VSS VDD \$12150 NOR2_X1
X$10547 \$11746 \$8316 VSS VDD \$11994 NAND2_X1
X$10548 \$11994 VSS VDD \$12096 INV_X1
X$10551 \$11802 \$8319 VSS VDD \$12151 NAND2_X1
X$10561 \$10244 VSS VDD \$10146 INV_X1
X$10562 VSS \$10187 \$10186 \$10511 \$10245 \$10146 VDD FA_X1
X$10566 \$7915 \$6674 VSS VDD \$10251 NAND2_X1
X$10573 VSS \$10444 \$I72363 \$7649 \$10394 \$5607 VDD DFFR_X1
X$10575 \$10143 VSS VDD \$10395 INV_X1
X$10579 VSS \$10246 \$10397 \$10400 \$10247 \$10399 VDD FA_X1
X$10580 VSS \$9371 \$10399 \$10255 \$10251 \$7615 VDD FA_X1
X$10581 \$10189 VSS VDD \$10517 INV_X1
X$10583 \$10255 VSS VDD \$10257 INV_X1
X$10585 \$6674 VSS VDD \$9997 INV_X1
X$10588 VSS \$9645 \$10353 \$10259 \$9826 \$10153 VDD FA_X1
X$10591 VSS \$10257 \$10519 \$10153 \$9380 \$10152 VDD FA_X1
X$10594 \$10259 VSS VDD \$10261 INV_X1
X$10596 VSS \$10192 \$10260 \$10262 \$10261 \$10156 VDD FA_X1
X$10598 \$10262 VSS VDD \$10102 INV_X1
X$10600 \$10161 \$10102 \$10193 VDD VSS \$10194 HA_X1
X$10602 \$10103 VSS VDD \$10268 INV_X1
X$10603 \$10268 \$8109 \$10274 VDD \$10267 VSS OAI21_X1
X$10604 \$8109 \$10103 VDD VSS \$10414 XNOR2_X1
X$10608 \$9747 VSS VDD \$10171 INV_X1
X$10609 \$10199 \$10171 VDD VSS \$10283 XNOR2_X1
X$10611 VSS \$9055 \$I72795 \$9391 \$10283 \$7479 VDD DFFR_X1
X$10615 \$10052 VSS VDD \$10043 INV_X1
X$10620 \$10358 \$10201 \$8564 VDD VSS \$10294 AND3_X1
X$10621 \$10294 \$10181 \$10292 VDD VSS \$10109 HA_X1
X$10624 \$10260 VSS VDD \$10354 INV_X1
X$10629 \$10194 \$10193 \$10267 VSS \$10452 VDD AOI21_X1
X$10632 \$10267 \$10193 VSS VDD \$10275 XOR2_X1
X$10633 \$1762 VSS VDD \$7670 CLKBUF_X3
X$10635 \$9745 VSS VDD \$9389 INV_X1
X$10641 \$10201 \$8316 VSS VDD \$10202 NAND2_X1
X$10644 \$10202 VSS VDD \$10290 INV_X1
X$10645 \$10290 \$10358 \$10181 VDD VSS \$10465 HA_X1
X$10648 \$10292 \$10203 \$8564 VSS VDD \$10298 NAND3_X1
X$10650 \$10298 VSS VDD \$10296 INV_X1
X$10651 \$10296 \$10427 \$10204 VDD VSS \$10110 HA_X1
X$10653 \$10204 \$10109 VSS VDD \$10299 NAND2_X1
X$10654 \$10110 VSS VDD \$10111 INV_X1
X$10656 \$10111 \$10299 VSS VDD \$10205 NAND2_X1
X$10664 VSS \$9716 \$I72591 \$10303 \$10203 \$10360 VDD DFFR_X1
X$10667 VSS \$9288 \$I72324 \$10329 \$10303 \$10208 VDD DFFR_X1
X$10668 VSS \$9288 \$I72821 \$4624 \$10112 \$7479 VDD DFFR_X1
X$10671 \$10308 VSS VDD \$9960 INV_X1
X$10672 \$10113 \$10308 VSS VDD \$10311 NAND2_X1
X$10676 \$10318 \$10115 VSS VDD \$10114 XOR2_X1
X$10678 \$10368 \$10115 \$10318 VSS \$9767 VDD AOI21_X1
X$10684 VSS \$10209 \$10308 \$9292 \$10361 \$10362 VDD FA_X1
X$10685 \$10436 \$10365 VDD VSS \$8930 XNOR2_X1
X$10686 \$10365 \$10581 \$10311 VSS \$10210 VDD AOI21_X1
X$10688 \$10210 \$10367 VSS VDD \$10318 OR2_X1
X$10690 \$10368 \$10115 \$10442 VSS \$9904 VDD AOI21_X1
X$10692 \$10119 VSS VDD \$10182 INV_X1
X$10694 VSS \$9092 \$I72844 \$10332 \$10614 \$9773 VDD DFFR_X1
X$10695 \$10332 VSS VDD \$10116 INV_X1
X$10696 VSS \$10079 \$I72891 \$10338 \$10117 \$9773 VDD DFFR_X1
X$10702 \$10339 VSS VDD \$10079 CLKBUF_X3
X$10703 VSS \$10079 \$I72867 \$10342 \$10338 \$9773 VDD DFFR_X1
X$10705 VSS \$10217 \$I72682 \$10219 \$10342 \$9773 VDD DFFR_X1
X$10706 VSS \$9771 \$I72754 \$5269 \$10219 \$9773 VDD DFFR_X1
X$10710 VSS \$10079 \$I72564 \$10343 \$10216 \$9773 VDD DFFR_X1
X$10711 VSS \$10217 \$I72402 \$4831 \$10343 \$9773 VDD DFFR_X1
X$10715 VSS \$9771 \$I72605 \$10221 \$9419 \$5920 VDD DFFR_X1
X$10724 \$9971 \$10167 VSS VDD \$4497 XNOR2_X2
X$10728 \$10222 \$10122 VDD VSS \$10169 XNOR2_X1
X$10729 \$10122 \$10222 \$10224 VDD \$10167 VSS OAI21_X1
X$10734 \$10223 \$10378 VDD VSS \$10119 XNOR2_X1
X$10735 \$10412 \$10378 \$10223 VSS \$10222 VDD AOI21_X1
X$10738 \$10125 VSS VDD \$10224 INV_X1
X$10739 \$10123 VSS VDD \$10122 INV_X1
X$10741 \$10328 VSS VDD \$10410 INV_X1
X$10743 \$10335 VSS VDD \$10279 INV_X1
X$10744 \$10336 VSS VDD \$10124 INV_X1
X$10745 \$10124 \$10164 \$10123 VDD VSS \$10125 HA_X1
X$10747 VSS \$10330 \$10336 \$10328 \$9980 \$10163 VDD FA_X1
X$10749 VSS \$10316 \$10330 \$10538 \$10323 \$10155 VDD FA_X1
X$10751 \$10279 \$8636 VSS VDD \$9430 NAND2_X1
X$10755 \$6624 \$8802 VSS VDD \$10229 NAND2_X1
X$10756 \$10229 VSS VDD \$10010 INV_X1
X$10758 \$9667 VSS VDD \$8636 INV_X4
X$10766 \$10126 VSS VDD \$10163 INV_X1
X$10772 \$10008 VSS VDD \$10531 INV_X1
X$10774 \$6624 \$8464 VSS VDD \$10228 NAND2_X1
X$10775 \$10228 VSS VDD \$10382 INV_X1
X$10776 \$10288 VSS VDD \$10526 INV_X1
X$10778 \$5269 \$8152 VSS VDD \$10288 NAND2_X1
X$10779 \$5269 \$7909 VSS VDD \$10489 NAND2_X1
X$10784 \$10279 \$7909 VSS VDD \$10234 NAND2_X1
X$10786 \$10133 \$9667 VSS VDD \$10233 NOR2_X1
X$10788 VSS \$10256 \$10682 \$10388 \$10234 \$10392 VDD FA_X1
X$10790 \$6156 \$8152 VSS VDD \$10256 NAND2_X1
X$10794 \$4825 VSS VDD \$10133 INV_X1
X$10795 \$4825 \$8464 VSS VDD \$10250 NAND2_X1
X$10796 \$4831 \$8152 VSS VDD \$10135 NAND2_X1
X$10797 \$10250 VSS VDD \$10144 INV_X1
X$10798 \$8651 \$10133 \$10135 VSS VDD \$10239 NOR3_X1
X$10799 \$10135 VSS VDD \$10145 INV_X1
X$10800 \$10144 \$10145 \$10235 VDD VSS \$10651 HA_X1
X$10805 \$10239 \$10235 \$10512 VDD VSS \$10504 HA_X1
X$10807 VSS \$9439 \$I72853 \$9317 \$9984 \$5920 VDD DFFR_X1
X$10849 VSS \$11266 \$7615 \$10937 \$11662 \$5607 VDD DFFR_X1
X$10854 VSS \$11489 \$I72850 \$11550 \$11542 \$10454 VDD DFFR_X1
X$10860 VSS \$11489 \$I72429 \$11787 \$10937 \$10454 VDD DFFR_X1
X$10862 \$11316 VSS VDD \$10938 CLKBUF_X3
X$10863 VSS \$10938 \$I72577 \$11790 \$11550 \$10454 VDD DFFR_X1
X$10866 VSS \$11063 \$11566 \$11565 \$11407 \$10454 VDD DFFR_X1
X$10867 VSS \$11063 \$I72780 \$11407 \$11556 \$10454 VDD DFFR_X1
X$10868 \$11566 VSS VDD \$11468 INV_X1
X$10873 VSS \$11063 \$I72288 \$11620 \$10275 \$10454 VDD DFFR_X1
X$10874 VSS \$11583 \$I72522 \$11499 \$10762 \$10454 VDD DFFR_X1
X$10878 \$10601 \$9192 VSS VDD \$11495 NAND2_X1
X$10880 \$11495 VSS VDD \$11466 INV_X1
X$10881 \$9389 \$10201 VDD VSS \$11575 AND2_X1
X$10882 \$11575 \$11466 \$11465 VDD VSS \$11496 HA_X1
X$10886 \$10201 \$9751 VSS VDD \$11809 NAND2_X1
X$10888 \$11565 \$8319 VSS VDD \$11497 NAND2_X1
X$10890 \$11497 VSS VDD \$11473 INV_X1
X$10894 \$10946 \$8201 VSS VDD \$11498 NAND2_X1
X$10895 \$11498 VSS VDD \$11625 INV_X1
X$10898 \$11367 VSS VDD \$11700 INV_X1
X$10900 \$11582 VSS VDD \$11501 INV_X1
X$10901 VSS \$11409 \$11582 \$11280 \$11698 \$11370 VDD FA_X1
X$10905 \$11699 VSS VDD \$11500 INV_X1
X$10907 VSS \$11501 \$11703 \$11704 \$11701 \$11700 VDD FA_X1
X$10912 \$11262 \$11588 \$11502 VDD VSS \$11593 HA_X1
X$10916 \$11704 VSS VDD \$11588 INV_X1
X$10917 \$11593 \$11502 \$11503 VSS \$11587 VDD AOI21_X1
X$10918 \$11503 \$11502 VDD VSS \$11840 XNOR2_X1
X$10922 VSS \$11750 \$I72365 \$11504 \$10201 \$10360 VDD DFFR_X1
X$10923 VSS \$11282 \$I72344 \$11715 \$11504 \$10360 VDD DFFR_X1
X$10924 \$11282 VSS VDD CLKBUF_X1
X$10925 VSS \$11282 \$I72917 \$11483 \$11752 \$10360 VDD DFFR_X1
X$10929 \$11479 VSS VDD \$11412 INV_X1
X$10931 VSS \$11282 \$I72321 \$11718 \$11715 \$10360 VDD DFFR_X1
X$10934 VSS \$11284 \$I72265 \$10959 \$11718 \$11529 VDD DFFR_X1
X$10935 \$11376 VSS VDD \$11284 CLKBUF_X3
X$10936 \$11284 VSS VDD CLKBUF_X1
X$10941 \$11288 \$11508 VDD VSS \$11479 XNOR2_X1
X$10947 \$11508 \$11288 VSS VDD \$11628 NAND2_X1
X$10949 \$11630 \$11629 \$11508 VDD VSS \$11727 HA_X1
X$10950 \$11726 VSS VDD \$11630 INV_X1
X$10951 VSS \$11615 \$11726 \$11509 \$11725 \$11510 VDD FA_X1
X$10953 \$11509 VSS VDD \$11476 INV_X1
X$10958 \$11728 VSS VDD \$11615 INV_X1
X$10960 \$11732 \$11721 \$11472 VDD VSS \$11728 HA_X1
X$10962 \$11731 VSS VDD \$11732 INV_X1
X$10965 \$11736 VSS VDD \$11510 INV_X1
X$10967 \$10615 \$11417 VSS VDD \$11512 NAND2_X1
X$10970 \$11512 VSS VDD \$11418 INV_X1
X$10972 \$11722 \$11418 \$11464 VDD VSS \$11513 HA_X1
X$10976 VSS \$11883 \$11736 \$11721 \$11291 \$11513 VDD FA_X1
X$10981 \$11639 \$11462 VDD VSS \$11712 XNOR2_X1
X$10983 \$11293 \$11417 \$11462 VDD VSS \$11294 HA_X1
X$10984 \$10339 VSS VDD \$10962 CLKBUF_X3
X$10985 \$10962 VSS VDD \$I74135 INV_X2
X$10989 \$11514 \$11462 VSS VDD \$11899 NAND2_X1
X$10990 VSS \$10962 \$I72470 \$11641 \$11712 \$11529 VDD DFFR_X1
X$10992 \$11462 VSS VDD \$11642 INV_X1
X$10993 \$11462 \$11297 VSS VDD \$11519 NAND2_X1
X$10994 \$11520 \$11642 \$11643 \$11519 \$11522 VDD VSS \$11961 OAI221_X1
X$10995 \$11519 \$11521 VSS VDD \$11645 NOR2_X1
X$10996 \$11419 VSS VDD \$11520 INV_X1
X$11000 \$11420 \$11520 \$11458 VSS VDD \$11589 NAND3_X1
X$11001 \$11297 \$11296 \$11456 VSS VDD \$11458 NAND3_X1
X$11002 \$11296 VSS VDD \$11421 INV_X1
X$11003 \$11424 \$11421 \$11422 VDD \$11584 VSS OAI21_X1
X$11005 \$11649 VSS VDD \$11524 INV_X1
X$11006 \$11423 \$11524 \$11424 VDD \$11456 VSS OAI21_X1
X$11008 \$11524 \$11674 \$11424 VDD \$11577 VSS OAI21_X1
X$11009 \$11525 VSS VDD \$11424 INV_X1
X$11010 \$11577 \$11421 VDD VSS \$11651 XNOR2_X1
X$11011 \$11450 \$11528 VDD VSS \$10960 AND2_X1
X$11016 \$11521 \$11765 \$11522 VDD \$11764 VSS OAI21_X1
X$11019 \$11649 \$11296 VSS VDD \$11521 NAND2_X1
X$11024 \$11584 VSS VDD \$11522 INV_X1
X$11028 \$11298 \$11675 \$11649 VDD VSS \$11525 HA_X1
X$11033 VSS \$10778 \$I72318 \$11528 \$11651 \$11529 VDD DFFR_X1
X$11034 VSS \$11531 \$I72904 \$11530 \$11562 \$11529 VDD DFFR_X1
X$11036 \$11450 \$11530 VDD VSS \$11451 AND2_X1
X$11040 VSS \$11531 \$I72285 \$11665 \$11561 \$11529 VDD DFFR_X1
X$11041 VSS \$11531 \$11655 \$11656 \$11233 \$11529 VDD DFFR_X1
X$11046 \$11427 \$11425 VDD VSS \$11414 XNOR2_X1
X$11048 \$11425 VSS VDD \$11554 INV_X1
X$11049 \$11554 \$11427 \$11428 VDD \$11299 VSS OAI21_X1
X$11050 \$11551 VSS VDD \$11428 INV_X1
X$11051 \$11549 \$11429 \$11425 VDD VSS \$11551 HA_X1
X$11055 \$11532 VSS VDD \$11561 INV_X1
X$11060 \$11548 VSS VDD \$11549 INV_X1
X$11062 \$11546 VSS VDD \$11533 INV_X1
X$11065 VSS \$11544 \$11548 \$11659 \$11533 \$11657 VDD FA_X1
X$11066 \$11302 VSS VDD \$11657 INV_X1
X$11069 \$11430 VSS VDD \$11544 INV_X1
X$11073 \$11432 \$11431 VDD VSS \$11289 XNOR2_X1
X$11075 \$11534 \$11431 \$11432 VSS \$11427 VDD AOI21_X1
X$11078 \$11659 VSS VDD \$11658 INV_X1
X$11080 \$11536 \$11658 \$11431 VDD VSS \$11534 HA_X1
X$11082 VSS \$11433 \$11536 \$11441 \$11535 \$11444 VDD FA_X1
X$11087 \$11440 VSS VDD \$11537 INV_X1
X$11088 \$11537 \$11434 VSS VDD \$11432 NAND2_X1
X$11116 VSS \$11489 \$I72931 \$12115 \$7613 \$10454 VDD DFFR_X1
X$11117 VSS \$11489 \$I72970 \$12208 \$12115 \$10454 VDD DFFR_X1
X$11131 VSS \$11489 \$I72451 \$12215 \$12208 \$10454 VDD DFFR_X1
X$11132 VSS \$11803 \$I72368 \$11746 \$12215 \$10454 VDD DFFR_X1
X$11134 \$11316 VSS VDD \$11803 CLKBUF_X3
X$11137 \$11803 VSS VDD \$I55762 INV_X1
X$11139 VSS \$12218 \$12261 \$12264 \$12220 \$12316 VDD FA_X1
X$11140 \$12089 VSS VDD \$12218 INV_X1
X$11143 \$11802 \$9192 VSS VDD \$12089 NAND2_X1
X$11147 \$9389 \$11746 VDD VSS \$12316 AND2_X1
X$11148 \$11988 \$8520 VSS VDD \$12220 NOR2_X1
X$11149 VSS \$12228 \$12319 \$12427 \$12226 \$12267 VDD FA_X1
X$11150 \$11988 \$8201 VSS VDD \$12226 NOR2_X1
X$11154 \$12163 VSS VDD \$12228 INV_X1
X$11156 \$11802 \$8520 VSS VDD \$12163 NAND2_X1
X$11159 \$11746 \$8520 VSS VDD \$12166 NAND2_X1
X$11160 \$12166 VSS VDD \$12322 INV_X1
X$11161 VSS \$12234 \$12269 \$12644 \$12233 \$12322 VDD FA_X1
X$11162 \$11802 \$8201 VSS VDD \$12167 NAND2_X1
X$11164 \$12167 VSS VDD \$12234 INV_X1
X$11167 \$12136 VSS VDD \$12142 INV_X1
X$11170 \$11746 \$8201 VSS VDD \$12136 NAND2_X1
X$11172 VSS \$11992 \$12168 \$12447 \$12141 \$12142 VDD FA_X1
X$11175 \$11565 \$8201 VSS VDD \$12173 NAND2_X1
X$11176 \$12173 VSS VDD \$12242 INV_X1
X$11177 VSS \$12245 \$12360 \$12174 \$12150 \$12096 VDD FA_X1
X$11178 \$12151 VSS VDD \$12245 INV_X1
X$11182 \$12158 \$12097 \$11749 VSS VDD \$12179 NAND3_X1
X$11183 \$12098 \$12158 VSS VDD \$12181 NAND2_X1
X$11188 \$12002 \$12001 VSS VDD \$12258 NAND2_X1
X$11192 VSS \$12184 \$I72934 \$11287 \$12185 \$11529 VDD DFFR_X1
X$11196 \$12168 VSS VDD \$12745 INV_X1
X$11199 \$11565 \$8520 VSS VDD \$12442 NAND2_X1
X$11201 \$10203 \$9192 VSS VDD \$12240 NAND2_X1
X$11205 \$10946 \$8520 VSS VDD \$12172 NAND2_X1
X$11206 \$12172 VSS VDD \$12241 INV_X1
X$11207 \$12240 VSS VDD \$12329 INV_X1
X$11208 VSS \$12241 \$12270 \$12332 \$12242 \$12329 VDD FA_X1
X$11210 VSS \$11997 \$12449 \$12153 \$12174 \$12332 VDD FA_X1
X$11212 \$11703 VSS VDD \$12273 INV_X1
X$11217 \$11587 \$12337 VDD VSS \$12275 XNOR2_X1
X$11218 \$11499 \$12275 \$12158 VDD VSS \$12276 HA_X1
X$11219 \$12158 \$12180 VSS VDD \$12253 NAND2_X1
X$11220 \$12182 \$12158 VDD VSS \$12277 XNOR2_X1
X$11221 \$12180 VSS VDD \$12182 INV_X1
X$11225 \$12001 \$11753 VSS VDD \$12465 NAND2_X1
X$11227 \$12258 \$12278 \$12156 VSS VDD \$12183 NAND3_X1
X$11228 \$12339 VSS VDD \$12278 INV_X1
X$11230 VSS \$12184 \$I72348 \$12185 \$12373 \$11529 VDD DFFR_X1
X$11234 VSS \$12186 \$12485 \$12144 \$12333 \$12280 VDD FA_X1
X$11235 \$12146 VSS VDD \$12186 INV_X1
X$11237 \$12144 VSS VDD \$12100 INV_X1
X$11240 \$12250 VSS VDD \$12280 INV_X1
X$11245 \$8287 VSS VDD \$8249 INV_X1
X$11249 \$7613 \$5973 VSS VDD \$8667 NAND2_X1
X$11255 VSS \$8338 \$8017 \$8479 \$8165 \$8476 VDD FA_X1
X$11256 VSS \$8339 \$8338 \$8386 \$8249 \$8478 VDD FA_X1
X$11257 VSS \$8340 \$8339 \$9274 \$8169 \$8408 VDD FA_X1
X$11259 \$8486 VSS VDD \$8340 INV_X1
X$11261 VSS \$8342 \$8486 \$8665 \$8251 \$8488 VDD FA_X1
X$11263 \$7615 \$5434 VSS VDD \$8251 NOR2_X1
X$11266 \$8254 \$5129 VSS VDD \$8255 NAND2_X1
X$11267 \$8255 VSS VDD \$8293 INV_X1
X$11268 \$8510 \$8293 \$8186 VDD VSS \$8513 HA_X1
X$11273 \$8256 VSS VDD \$8257 INV_X1
X$11275 \$8492 VSS VDD \$8342 INV_X1
X$11277 \$7649 \$5674 VSS VDD \$8492 NAND2_X1
X$11280 \$7613 \$5434 VSS VDD \$8410 NAND2_X1
X$11283 \$8254 \$5434 VSS VDD \$8500 NAND2_X1
X$11286 \$7915 \$5674 VSS VDD \$8348 NAND2_X1
X$11288 \$8348 VSS VDD \$8398 INV_X1
X$11290 VSS \$8399 \$8856 \$8516 \$8513 \$8414 VDD FA_X1
X$11292 \$8506 VSS VDD \$8351 INV_X1
X$11294 \$8351 \$8516 \$8350 VDD VSS \$8517 HA_X1
X$11295 \$8517 VSS VDD \$8415 INV_X1
X$11298 \$8352 \$8520 \$8416 VDD VSS \$8417 HA_X1
X$11299 \$8416 VSS VDD \$8353 INV_X1
X$11300 \$8417 VSS VDD \$8421 INV_X1
X$11301 \$8258 \$8353 \$8421 VDD \$8420 VSS OAI21_X1
X$11304 \$8261 \$8257 \$8258 VDD \$8306 VSS OAI21_X1
X$11306 \$8306 VSS VDD \$8310 INV_X1
X$11307 \$8305 \$8111 \$8310 VDD \$8597 VSS OAI21_X1
X$11308 \$8256 \$8110 VSS VDD \$8305 NAND2_X1
X$11309 \$8260 \$8316 \$8110 VDD VSS \$8315 HA_X1
X$11310 \$8315 VSS VDD \$8261 INV_X1
X$11314 \$8257 \$8525 \$8258 VDD \$8418 VSS OAI21_X1
X$11315 \$8356 VSS VDD \$8525 INV_X1
X$11317 \$8356 \$8257 VDD VSS \$8598 XNOR2_X1
X$11320 \$8422 \$8533 \$8261 VDD \$8356 VSS OAI21_X1
X$11321 \$8114 VSS VDD \$8262 INV_X1
X$11325 \$8110 VSS VDD \$8422 INV_X1
X$11326 \$8359 \$8422 \$8261 \$8423 \$8425 VDD VSS \$8539 OAI221_X1
X$11328 \$8110 \$8358 VSS VDD \$8423 NAND2_X1
X$11330 \$8028 \$8319 \$8358 VDD VSS \$8263 HA_X1
X$11333 \$8027 VSS VDD CLKBUF_X1
X$11334 \$6665 VSS VDD \$8027 CLKBUF_X3
X$11340 VSS \$8611 \$I72733 \$3568 \$8579 \$7479 VDD DFFR_X1
X$11343 VSS \$8328 \$8783 \$8753 \$8266 \$7837 VDD FA_X1
X$11344 VSS \$7840 \$8265 \$8752 \$8266 \$8227 VDD FA_X1
X$11345 VSS \$8267 \$8436 \$8572 \$8266 \$7975 VDD FA_X1
X$11348 \$8263 \$8358 \$8600 VSS \$8533 VDD AOI21_X1
X$11349 \$8263 VSS VDD \$8359 INV_X1
X$11351 \$8563 \$8358 VSS VDD \$8360 NAND2_X1
X$11352 \$8360 \$8359 \$8555 VSS VDD \$8429 NAND3_X1
X$11353 \$8115 \$8564 \$8430 VDD VSS \$8563 HA_X1
X$11354 \$8563 VSS VDD \$8431 INV_X1
X$11357 VSS \$8027 \$I72567 \$8394 \$8573 \$7479 VDD DFFR_X1
X$11358 VSS \$8027 \$I72514 \$8779 \$8362 \$7479 VDD DFFR_X1
X$11359 VSS \$8611 \$I72511 \$8612 \$8101 \$7479 VDD DFFR_X1
X$11361 \$8218 VSS VDD \$8745 INV_X1
X$11366 \$8615 \$8583 VDD VSS \$8363 XNOR2_X1
X$11367 \$8363 \$8121 VDD VSS \$9237 XNOR2_X1
X$11372 \$8572 VSS VDD \$8437 INV_X1
X$11373 \$8566 VSS VDD \$8615 INV_X1
X$11375 \$8123 VSS VDD \$8744 INV_X1
X$11376 VSS \$8126 \$8981 \$8566 \$8268 \$8034 VDD FA_X1
X$11378 \$8125 \$8124 \$8268 VDD VSS \$8126 HA_X1
X$11379 \$8268 VSS VDD \$8335 INV_X1
X$11382 VSS \$8335 \$8390 \$8332 \$7751 \$8336 VDD FA_X1
X$11385 VSS \$7849 \$8548 \$8270 \$8269 \$8329 VDD FA_X1
X$11387 VSS \$8131 \$8271 \$8540 \$7681 \$8273 VDD FA_X1
X$11388 \$8037 \$8239 \$8731 VDD VSS \$8367 HA_X1
X$11392 \$8326 \$7148 \$8324 VDD VSS \$8368 HA_X1
X$11393 \$8134 VSS VDD \$8326 INV_X1
X$11398 VSS \$8126 \$8438 \$8439 \$8268 \$7787 VDD FA_X1
X$11401 VSS \$8126 \$8441 \$8443 \$8268 \$8442 VDD FA_X1
X$11403 VSS \$7181 \$8560 \$8557 \$8268 \$8126 VDD FA_X1
X$11404 \$8557 VSS VDD \$8444 INV_X1
X$11407 VSS \$7847 \$8737 \$8736 \$7753 \$8332 VDD FA_X1
X$11408 \$8244 VSS VDD \$8549 INV_X1
X$11411 \$8548 VSS VDD \$8628 INV_X1
X$11415 \$8130 VSS VDD \$8543 INV_X1
X$11416 \$8270 VSS VDD \$8445 INV_X1
X$11419 \$8271 VSS VDD \$8631 INV_X1
X$11423 VSS \$8367 \$8446 \$8532 \$8540 \$8083 VDD FA_X1
X$11428 \$8531 VSS VDD \$8448 INV_X1
X$11432 VSS \$8135 \$8450 \$8452 \$8369 \$8451 VDD FA_X1
X$11434 \$8324 VSS VDD \$8369 INV_X1
X$11436 \$7852 VSS VDD \$8451 INV_X1
X$11440 \$7855 \$8231 VDD VSS \$8318 XNOR2_X1
X$11441 \$7779 \$8137 VDD VSS \$8231 XNOR2_X1
X$11443 \$8140 \$8220 \$8321 VDD VSS \$8143 HA_X1
X$11448 \$8143 VSS VDD \$8146 INV_X1
X$11449 \$8321 VSS VDD \$8145 INV_X1
X$11450 \$8145 \$8300 \$8146 VDD \$8370 VSS OAI21_X1
X$11451 \$8313 \$8211 \$8274 VDD VSS \$8275 HA_X1
X$11452 \$8275 \$8274 \$8291 VSS \$8300 VDD AOI21_X1
X$11453 \$8274 VSS VDD \$8276 INV_X1
X$11455 \$8370 \$8318 VDD VSS \$8388 XNOR2_X1
X$11459 \$8276 \$8277 \$8147 VDD \$8371 VSS OAI21_X1
X$11460 \$8275 VSS VDD \$8147 INV_X1
X$11463 \$8371 \$8145 VDD VSS \$8704 XNOR2_X1
X$11465 \$8291 \$8276 VDD VSS \$8278 XNOR2_X1
X$11469 VSS \$8458 \$I72925 \$8279 \$8043 \$5920 VDD DFFR_X1
X$11474 VSS \$8458 \$I72403 \$8461 \$8278 \$5920 VDD DFFR_X1
X$11477 \$8697 \$8373 VSS VDD \$8374 NAND2_X1
X$11478 \$8374 \$8070 \$8463 VDD \$8462 VSS OAI21_X1
X$11479 \$8279 \$8464 \$8373 VDD VSS \$8509 HA_X1
X$11480 \$8509 VSS VDD \$8465 INV_X1
X$11482 \$8070 \$8373 VDD VSS \$8385 XNOR2_X1
X$11484 VSS \$8644 \$I72626 \$8681 \$8385 \$5920 VDD DFFR_X1
X$11487 \$8373 VSS VDD \$8375 INV_X1
X$11488 \$8375 \$8289 \$8465 VDD \$8384 VSS OAI21_X1
X$11489 \$8151 VSS VDD \$8194 INV_X1
X$11490 \$8151 \$7860 \$8286 VSS \$8289 VDD AOI21_X1
X$11492 \$8154 VSS VDD \$8280 INV_X1
X$11494 \$6298 \$8281 VDD VSS \$8052 AND2_X1
X$11495 VSS \$8644 \$I72868 \$8281 \$8055 \$5920 VDD DFFR_X1
X$11502 \$8373 \$7860 VSS VDD \$8376 NAND2_X1
X$11504 \$8194 \$8375 \$8465 \$8376 \$8280 VDD VSS \$8469 OAI221_X1
X$11506 \$8376 \$8045 VSS VDD \$8832 NOR2_X1
X$11507 \$7860 VSS VDD \$8381 INV_X1
X$11508 \$8045 \$7770 \$8280 VDD \$8286 VSS OAI21_X1
X$11544 VSS \$12345 \$I72291 \$8106 \$12809 \$5607 VDD DFFR_X1
X$11549 VSS \$12724 \$I72271 \$12819 \$12814 \$5607 VDD DFFR_X1
X$11554 \$12589 \$12824 VDD VSS \$12774 XNOR2_X1
X$11557 \$12347 \$12631 VDD VSS \$12683 XNOR2_X1
X$11560 \$12731 \$9751 VSS VDD \$12684 NAND2_X1
X$11563 VSS \$12729 \$12824 \$12978 \$12826 \$12734 VDD FA_X1
X$11564 \$11802 \$11746 VSS VDD \$12731 XOR2_X1
X$11565 VSS \$12740 \$12735 \$12589 \$12592 \$12490 VDD FA_X1
X$11566 VSS \$11908 \$12631 \$12734 \$12491 \$12735 VDD FA_X1
X$11567 \$12429 VSS VDD \$12592 INV_X1
X$11568 \$12593 VSS VDD \$12740 INV_X1
X$11569 \$10946 \$9751 VSS VDD \$12593 NAND2_X1
X$11574 \$12590 VSS VDD \$12951 INV_X1
X$11575 \$12778 VSS VDD \$12779 INV_X1
X$11577 \$12746 VSS VDD \$12747 INV_X1
X$11578 VSS \$12356 \$12986 \$12746 \$12743 \$12592 VDD FA_X1
X$11582 VSS \$12745 \$12780 \$12748 \$12687 \$12747 VDD FA_X1
X$11583 VSS \$12493 \$12782 \$12749 \$12748 \$12840 VDD FA_X1
X$11585 VSS \$12688 \$12918 \$12842 \$12749 \$12649 VDD FA_X1
X$11586 \$12842 VSS VDD \$12845 INV_X1
X$11589 \$12844 \$12845 \$12783 VDD VSS \$12919 HA_X1
X$11591 \$12689 VSS VDD \$12844 INV_X1
X$11593 \$12364 \$12783 VDD VSS \$12690 XNOR2_X1
X$11595 \$12690 VSS VDD \$12595 INV_X1
X$11599 VSS \$12753 \$I72724 \$12598 \$12502 \$10360 VDD DFFR_X1
X$11601 \$12783 \$12364 VSS VDD \$12784 NAND2_X1
X$11603 \$12562 VSS VDD \$12922 INV_X1
X$11605 VSS \$11583 \$I72580 \$12854 \$11802 \$10360 VDD DFFR_X1
X$11608 VSS \$12753 \$I72752 \$12754 \$12598 \$11529 VDD DFFR_X1
X$11612 \$12754 \$12670 \$12599 VDD VSS \$12601 HA_X1
X$11614 \$12581 \$12601 VSS VDD \$12694 OR2_X1
X$11617 \$12600 VSS VDD \$12996 INV_X1
X$11618 \$12694 \$12790 VSS VDD \$12756 XOR2_X1
X$11621 \$12376 \$12695 VDD VSS \$12603 XNOR2_X1
X$11622 \$12603 VSS VDD \$12670 INV_X1
X$11623 \$12695 \$12376 VSS VDD \$12696 NAND2_X1
X$11629 \$12791 \$12696 VSS VDD \$12792 NAND2_X1
X$11630 \$12766 VSS VDD \$12791 INV_X1
X$11633 \$12697 \$12793 \$12695 VDD VSS \$12766 HA_X1
X$11634 \$12860 VSS VDD \$12697 INV_X1
X$11637 \$10615 \$12604 VSS VDD \$12944 NAND2_X1
X$11638 \$12604 \$10959 VDD VSS \$12605 AND2_X1
X$11640 \$12795 VSS VDD \$12606 INV_X1
X$11643 VSS \$12384 \$12767 \$12551 \$12765 \$12855 VDD FA_X1
X$11645 \$12607 \$11191 VSS VDD \$12610 NOR2_X1
X$11648 \$12612 \$12614 VDD VSS \$12742 XNOR2_X1
X$11649 \$12613 VSS VDD \$12614 INV_X1
X$11650 \$12705 \$12613 \$12612 VSS \$12838 VDD AOI21_X1
X$11651 \$12705 VSS VDD \$12635 INV_X1
X$11655 \$12391 VSS VDD \$I56527 INV_X1
X$11656 \$10339 VSS VDD \$12391 CLKBUF_X3
X$11661 \$10959 \$12870 VSS VDD \$12796 NAND2_X1
X$11665 \$12673 VSS VDD \$12887 INV_X1
X$11670 \$12767 VSS VDD \$12869 INV_X1
X$11671 \$11292 \$12006 VSS VDD \$12699 NAND2_X1
X$11672 \$12699 VSS VDD \$12798 INV_X1
X$11673 \$12764 VSS VDD \$12759 INV_X1
X$11675 \$11295 \$11417 VSS VDD \$12764 NAND2_X1
X$11680 \$12615 \$12604 \$12613 VDD VSS \$12705 HA_X1
X$11682 VSS \$12391 \$I72499 \$12394 \$12742 \$11529 VDD DFFR_X1
X$11685 \$12802 \$12801 \$11929 VSS VDD \$12709 NAND3_X1
X$11686 \$12615 \$12818 \$12802 VDD VSS \$12833 HA_X1
X$11687 \$12833 VSS VDD \$12711 INV_X1
X$11688 \$12710 \$12627 VDD VSS \$12617 XNOR2_X1
X$11691 VSS \$12391 \$12520 \$12714 \$12617 \$11529 VDD DFFR_X1
X$11693 \$12520 \$12720 \$12716 VDD VSS \$12620 HA_X1
X$11694 \$12716 VSS VDD \$12715 INV_X1
X$11710 \$12832 \$12711 \$12709 VSS VDD \$12710 NAND3_X1
X$11715 \$12805 VSS VDD \$12392 INV_X1
X$11716 \$12806 \$12394 \$12805 \$12714 VSS VDD \$12720 NAND4_X1
X$11717 \$12403 \$12521 \$12870 VSS VDD NOR2_X4
X$11719 \$12521 \$12715 \$12392 VSS \$12818 VDD AOI21_X1
X$11748 xin[5] VSS VDD \$13186 BUF_X1
X$11753 VSS \$12724 \$I72614 \$13167 \$13363 \$5607 VDD DFFR_X1
X$11754 xin[2] VSS VDD \$13363 BUF_X1
X$11771 VSS \$12724 \$I72513 \$13341 \$8760 \$5607 VDD DFFR_X1
X$11772 VSS \$13388 \$I72441 \$13414 \$13341 \$5607 VDD DFFR_X1
X$11773 VSS \$13388 \$I72461 \$13342 \$13414 \$5607 VDD DFFR_X1
X$11774 VSS \$13388 \$I72430 \$10946 \$13342 \$5607 VDD DFFR_X1
X$11778 VSS \$13228 \$I72601 \$13372 \$13266 \$10360 VDD DFFR_X1
X$11779 VSS \$13228 \$I72629 \$13266 \$10946 \$10360 VDD DFFR_X1
X$11780 VSS \$13228 \$I72640 \$13374 \$13372 \$10360 VDD DFFR_X1
X$11781 VSS \$13228 \$I72621 \$13268 \$13318 \$10360 VDD DFFR_X1
X$11782 VSS \$13133 \$I72624 \$11292 \$13374 \$10360 VDD DFFR_X1
X$11784 \$13349 VSS VDD \$13134 INV_X1
X$11785 \$13134 \$13231 \$13269 VDD \$13350 VSS OAI21_X1
X$11786 \$13351 VSS VDD \$13269 INV_X1
X$11793 VSS \$13228 \$I72448 \$13423 \$13314 \$10360 VDD DFFR_X1
X$11795 \$11376 VSS VDD \$13228 CLKBUF_X3
X$11796 \$13228 VSS VDD CLKBUF_X1
X$11799 VSS \$13228 \$I72251 \$13428 \$13423 \$10360 VDD DFFR_X1
X$11800 VSS \$13133 \$I72317 \$13430 \$13268 \$10360 VDD DFFR_X1
X$11801 \$13428 VSS VDD \$13431 INV_X1
X$11802 \$13430 \$13432 \$13349 VDD VSS \$13351 HA_X1
X$11803 \$13350 \$13431 VDD VSS \$13451 XNOR2_X1
X$11806 \$13433 VSS VDD \$13432 INV_X1
X$11809 \$13271 \$13391 VDD VSS \$13433 XNOR2_X1
X$11812 \$13391 \$13271 \$13393 VDD \$13439 VSS OAI21_X1
X$11813 \$13394 \$13439 VDD VSS \$10612 XNOR2_X1
X$11816 \$13384 VSS VDD \$13329 INV_X1
X$11820 \$10117 \$11295 VSS VDD \$13447 XOR2_X1
X$11824 VSS \$13379 \$13382 \$13321 \$13380 \$13353 VDD FA_X1
X$11825 \$12604 \$11292 VDD VSS \$13379 AND2_X1
X$11828 \$13234 VSS VDD \$13353 INV_X1
X$11829 \$11292 \$12870 VSS VDD \$13276 NAND2_X1
X$11830 \$13276 VSS VDD \$13354 INV_X1
X$11831 \$13277 VSS VDD \$13438 INV_X1
X$11834 \$10117 \$12604 VSS VDD \$13356 NAND2_X1
X$11837 VSS \$13445 \$13396 \$13384 \$13435 \$13397 VDD FA_X1
X$11841 \$12510 VSS VDD \$13395 INV_X1
X$11843 \$13447 \$12870 VSS VDD \$13517 NAND2_X1
X$11845 \$13398 VSS VDD \$13352 INV_X1
X$11849 \$13440 VSS VDD \$13458 INV_X1
X$11853 VSS \$13354 \$13461 \$13464 \$13353 \$13438 VDD FA_X1
X$11856 VSS \$13356 \$13512 \$13418 \$13436 \$13410 VDD FA_X1
X$11857 \$11295 \$12870 VSS VDD \$13410 NAND2_X1
X$11859 \$10117 \$12290 VSS VDD \$13358 NAND2_X1
X$11861 \$13358 VSS VDD \$13359 INV_X1
X$11881 \$12604 \$11295 VDD VSS \$13401 AND2_X1
X$11923 VSS \$5961 \$I72593 \$6157 \$6023 \$4645 VDD DFFR_X1
X$11924 \$5965 \$5807 \$5964 VSS \$6205 VDD AOI21_X1
X$11926 \$5808 \$5935 \$5663 VDD \$5964 VSS OAI21_X1
X$11927 \$4351 \$5973 \$5807 VDD VSS \$5965 HA_X1
X$11929 \$5965 \$5807 \$5969 VSS \$6312 VDD AOI21_X1
X$11931 \$5961 VSS VDD CLKBUF_X1
X$11932 \$5663 \$5874 \$5968 VDD \$6159 VSS OAI21_X1
X$11933 \$5965 VSS VDD \$5968 INV_X1
X$11934 \$5969 \$5874 VDD VSS \$6047 XNOR2_X1
X$11936 \$5874 \$5808 \$6043 VSS VDD \$5396 NOR3_X1
X$11941 VSS \$5961 \$I72578 \$5972 \$6047 \$4645 VDD DFFR_X1
X$11943 VSS \$5961 \$I72664 \$5879 \$6042 \$4645 VDD DFFR_X1
X$11947 \$4933 \$5972 VDD VSS \$5973 AND2_X1
X$11949 \$4933 \$5879 VDD VSS \$5674 AND2_X1
X$11952 \$5972 \$6217 \$5880 \$5879 VSS VDD \$6221 NOR4_X1
X$11955 \$4488 VSS VDD \$5612 CLKBUF_X3
X$11956 \$5612 VSS VDD \$I56128 INV_X1
X$11958 \$5882 \$5884 VDD VSS \$5883 XNOR2_X1
X$11959 \$5614 \$5883 VDD VSS \$6065 XNOR2_X1
X$11961 \$5884 VSS VDD \$5885 INV_X1
X$11965 \$5944 \$4933 VSS VDD \$6162 NAND2_X1
X$11966 \$6059 \$5881 \$4981 \$6221 VSS VDD \$6524 NAND4_X1
X$11970 \$5749 \$6164 VDD VSS \$6475 XNOR2_X1
X$11973 VSS \$5832 \$6165 \$6344 \$5885 \$5979 VDD FA_X1
X$11975 VSS \$5949 \$5979 \$5980 \$5613 \$5950 VDD FA_X1
X$11977 \$6229 VSS VDD \$5613 INV_X1
X$11979 \$5980 VSS VDD \$6339 INV_X1
X$11982 VSS \$6074 \$6347 \$6231 \$6076 \$6229 VDD FA_X1
X$11983 \$5981 VSS VDD \$5950 INV_X1
X$11985 VSS \$6079 \$5981 \$6076 \$6075 \$5886 VDD FA_X1
X$11986 \$5887 VSS VDD \$6079 INV_X1
X$11988 \$4752 \$5467 VSS VDD \$6075 NOR2_X1
X$11991 VSS \$5982 \$6074 \$5983 \$6092 \$6089 VDD FA_X1
X$11995 \$5476 \$5467 VSS VDD \$6092 NOR2_X1
X$11996 \$5619 \$4752 VSS VDD \$5984 NAND2_X1
X$11997 \$5984 VSS VDD \$5892 INV_X1
X$12002 \$5890 VSS VDD \$6089 INV_X1
X$12004 \$6088 VSS VDD \$6256 INV_X1
X$12005 \$5983 VSS VDD \$6355 INV_X1
X$12009 \$6096 VSS VDD \$6234 INV_X1
X$12011 \$6098 VSS VDD \$6166 INV_X1
X$12013 \$5985 VSS VDD \$5958 INV_X1
X$12014 \$5619 \$5476 VSS VDD \$5985 NAND2_X1
X$12015 VSS \$5986 \$6098 \$5987 \$6104 \$5958 VDD FA_X1
X$12017 \$4847 \$5467 VSS VDD \$6104 NOR2_X1
X$12021 \$5987 VSS VDD \$6167 INV_X1
X$12026 VSS \$5988 \$6168 \$6372 \$6106 \$6238 VDD FA_X1
X$12028 \$5898 VSS VDD \$5988 INV_X1
X$12029 \$5619 \$4632 VSS VDD \$6112 NAND2_X1
X$12030 \$5283 \$5467 VSS VDD \$6106 NOR2_X1
X$12034 \$6112 VSS VDD \$6238 INV_X1
X$12039 \$5901 VSS VDD \$6241 INV_X1
X$12041 \$5619 \$4847 VSS VDD \$5989 NAND2_X1
X$12043 \$5989 VSS VDD \$6169 INV_X1
X$12045 VSS \$5620 \$I72987 \$6120 \$5398 \$5084 VDD DFFR_X1
X$12047 VSS \$5620 \$I72734 \$6129 \$5619 \$5084 VDD DFFR_X1
X$12050 VSS \$5620 \$I72959 \$6133 \$6129 \$5084 VDD DFFR_X1
X$12053 VSS \$5596 \$I72755 \$5905 \$6133 \$5084 VDD DFFR_X1
X$12056 \$5596 VSS VDD CLKBUF_X1
X$12057 \$5997 VSS VDD \$5596 CLKBUF_X3
X$12065 \$5619 \$5283 VSS VDD \$6170 NAND2_X1
X$12068 VSS \$5620 \$I72457 \$6244 \$6120 \$5084 VDD DFFR_X1
X$12075 VSS \$5596 \$I72452 \$5995 \$6137 \$5084 VDD DFFR_X1
X$12077 VSS \$5625 \$I72568 \$6144 \$5995 \$5084 VDD DFFR_X1
X$12078 VSS \$5625 \$I72539 \$6233 \$6144 \$5084 VDD DFFR_X1
X$12080 VSS \$5775 \$I72695 \$4634 \$6156 \$5851 VDD DFFR_X1
X$12084 \$5730 VSS VDD \$6436 INV_X1
X$12085 \$5997 VSS VDD \$5775 CLKBUF_X3
X$12088 VSS \$5775 \$I72742 \$4311 \$6138 \$5851 VDD DFFR_X1
X$12090 \$5779 VSS VDD CLKBUF_X1
X$12091 \$5997 VSS VDD \$5779 CLKBUF_X3
X$12092 VSS \$5779 \$I72718 \$5909 \$5905 \$5851 VDD DFFR_X1
X$12093 VSS \$6001 \$I72661 \$5910 \$5909 \$5851 VDD DFFR_X1
X$12094 VSS \$6001 \$I73004 \$4865 \$5910 \$4460 VDD DFFR_X1
X$12108 \$5707 VSS VDD \$6001 CLKBUF_X3
X$12110 VSS \$5483 \$I72746 \$5911 \$6233 \$4460 VDD DFFR_X1
X$12112 VSS \$5325 \$I72826 \$5912 \$5911 \$4460 VDD DFFR_X1
X$12115 \$6128 \$5913 \$6005 VDD VSS \$6188 HA_X1
X$12123 \$4100 \$5635 VSS VDD \$6608 NOR2_X1
X$12124 \$4822 \$4100 VSS VDD \$6004 NAND2_X1
X$12125 \$4865 \$4599 VSS VDD \$6118 NAND2_X1
X$12130 VSS \$6010 \$6008 \$6011 \$6067 \$5515 VDD FA_X1
X$12131 \$5918 VSS VDD \$6067 INV_X1
X$12135 VSS \$5794 \$I72644 \$6015 \$5109 \$5920 VDD DFFR_X1
X$12137 \$6004 VSS VDD \$6352 INV_X1
X$12138 \$6118 VSS VDD \$6216 INV_X1
X$12141 \$6005 VSS VDD \$6087 INV_X1
X$12142 VSS \$6087 \$6213 \$6210 \$6007 \$5933 VDD FA_X1
X$12145 \$6082 VSS VDD \$6208 INV_X1
X$12148 \$6009 VSS VDD \$6292 INV_X1
X$12152 \$6011 VSS VDD \$6190 INV_X1
X$12156 VSS \$5794 \$I72277 \$6294 \$6206 \$5920 VDD DFFR_X1
X$12157 \$6015 \$6204 \$6206 VDD VSS \$6201 HA_X1
X$12158 VSS \$5794 \$I72945 \$6194 \$5923 \$5920 VDD DFFR_X1
X$12159 VSS \$6017 \$6035 \$5795 \$6018 \$5921 VDD FA_X1
X$12166 \$5707 VSS VDD \$5794 CLKBUF_X3
X$12167 \$6201 VSS VDD \$6017 INV_X1
X$12172 \$5922 \$6195 \$6200 VDD VSS \$6197 HA_X1
X$12173 \$6018 VSS VDD \$6195 INV_X1
X$12184 VSS \$7065 \$I72834 \$7119 \$6157 \$4645 VDD DFFR_X1
X$12190 \$4222 VSS VDD yout[1] BUF_X1
X$12200 VSS \$7065 \$I72570 \$7384 \$7119 \$4645 VDD DFFR_X1
X$12203 \$7065 VSS VDD CLKBUF_X1
X$12204 \$4488 VSS VDD \$7065 CLKBUF_X3
X$12205 \$6902 VSS VDD \$7121 INV_X1
X$12206 \$7122 \$7121 VDD VSS \$7120 XNOR2_X1
X$12208 VSS \$7065 \$I72809 \$6908 \$7120 \$4645 VDD DFFR_X1
X$12211 \$6682 VSS VDD \$6906 INV_X1
X$12213 VSS \$7324 \$6909 \$6682 \$7132 \$4645 VDD DFFR_X1
X$12216 \$6685 VSS VDD \$7195 INV_X1
X$12218 \$7138 VSS VDD \$7268 INV_X1
X$12220 \$7066 \$6687 \$7270 VDD VSS \$7196 HA_X1
X$12221 \$7142 VSS VDD \$7066 INV_X1
X$12222 VSS \$7141 \$7142 \$7274 \$6688 \$6912 VDD FA_X1
X$12227 \$5607 VSS VDD \$4645 BUF_X2
X$12231 \$4358 VSS VDD \$7063 INV_X1
X$12234 \$7267 \$7194 VDD VSS \$7325 XNOR2_X1
X$12235 \$7195 \$7269 \$7268 VDD \$7267 VSS OAI21_X1
X$12236 \$7196 \$7270 \$7543 VSS \$7269 VDD AOI21_X1
X$12237 \$7270 VSS VDD \$7326 INV_X1
X$12238 \$7196 VSS VDD \$7197 INV_X1
X$12243 \$7274 VSS VDD \$7411 INV_X1
X$12245 \$7145 VSS VDD \$7016 INV_X1
X$12251 \$7275 VSS VDD \$7328 INV_X1
X$12254 VSS \$6694 \$7417 \$7198 \$6416 \$7067 VDD FA_X1
X$12256 \$6915 VSS VDD \$7067 INV_X1
X$12260 \$6916 VSS VDD \$7332 INV_X1
X$12263 VSS \$6501 \$7199 \$7069 \$7146 \$7068 VDD FA_X1
X$12265 VSS \$6420 \$7201 \$7072 \$7070 \$7071 VDD FA_X1
X$12270 \$7279 VSS VDD \$7068 INV_X1
X$12273 VSS \$7201 \$7333 \$7422 \$7069 \$7200 VDD FA_X1
X$12282 VSS \$7280 \$7202 \$7203 \$7072 \$7073 VDD FA_X1
X$12283 \$6918 VSS VDD \$7073 INV_X1
X$12284 \$7150 VSS VDD \$7280 INV_X1
X$12289 VSS \$7152 \$7150 \$7281 \$6263 \$7074 VDD FA_X1
X$12292 \$7281 VSS VDD \$7430 INV_X1
X$12294 \$7075 VSS VDD \$7431 INV_X1
X$12296 VSS \$6847 \$7075 \$7205 \$6653 \$7157 VDD FA_X1
X$12301 VSS \$7043 \$7204 \$7435 \$7034 \$7205 VDD FA_X1
X$12305 VSS \$6922 \$7493 \$7209 \$7289 \$7208 VDD FA_X1
X$12306 \$7166 \$7163 \$7292 VDD VSS \$7164 HA_X1
X$12307 \$7164 VSS VDD \$7289 INV_X1
X$12308 \$7167 \$7165 \$7299 VDD VSS \$7168 HA_X1
X$12312 \$7295 VSS VDD \$7208 INV_X1
X$12313 \$7292 \$7299 \$7303 VDD VSS \$7448 HA_X1
X$12315 \$7172 \$7171 VSS VDD \$7211 NAND2_X1
X$12316 \$6721 \$7303 \$7172 VDD VSS \$7305 HA_X1
X$12323 \$7305 VSS VDD \$7076 INV_X1
X$12324 \$7076 \$7211 VSS VDD \$7966 NAND2_X1
X$12328 \$5181 \$5905 VSS VDD \$7311 NAND2_X1
X$12329 \$5437 \$5579 VSS VDD \$7217 NAND2_X1
X$12330 \$7217 VSS VDD \$7218 INV_X1
X$12332 \$7311 VSS VDD \$7459 INV_X1
X$12333 \$5727 \$6436 VSS VDD \$7461 NOR2_X1
X$12335 \$5905 \$5579 VSS VDD \$7078 NAND2_X1
X$12337 \$7078 VSS VDD \$7187 INV_X1
X$12338 VSS \$7189 \$7079 \$7319 \$7185 \$7187 VDD FA_X1
X$12339 \$5861 \$6180 VSS VDD \$7081 NAND2_X1
X$12340 \$7081 VSS VDD \$7175 INV_X1
X$12344 \$7079 VSS VDD \$7503 INV_X1
X$12347 \$7319 VSS VDD \$7220 INV_X1
X$12349 VSS \$6932 \$7181 \$7173 \$7178 \$7175 VDD FA_X1
X$12353 \$7173 VSS VDD \$7056 INV_X1
X$12358 \$7084 VSS VDD \$7170 INV_X1
X$12359 \$4754 \$6562 VSS VDD \$7084 NAND2_X1
X$12371 \$5371 \$6562 VSS VDD \$7087 NAND2_X1
X$12372 \$7087 VSS VDD \$7153 INV_X1
X$12375 \$4940 \$6732 VSS VDD \$7318 NAND2_X1
X$12376 VSS \$7302 \$7149 \$7148 \$7153 \$7089 VDD FA_X1
X$12380 \$5721 \$4940 VSS VDD \$7231 NAND2_X1
X$12382 \$6233 \$4754 VSS VDD \$7093 NAND2_X1
X$12383 \$7093 VSS VDD \$7094 INV_X1
X$12390 VSS \$6746 \$7096 \$7135 \$6005 \$6188 VDD FA_X1
X$12392 \$4940 \$6562 VSS VDD \$7225 NAND2_X1
X$12393 \$7225 VSS VDD \$7352 INV_X1
X$12395 \$4754 \$6732 VSS VDD \$7226 NAND2_X1
X$12396 \$7226 VSS VDD \$7228 INV_X1
X$12399 \$7318 VSS VDD \$7302 INV_X1
X$12408 \$5721 \$4754 VSS VDD \$7585 NAND2_X1
X$12410 \$7231 VSS VDD \$7286 INV_X1
X$12411 \$7286 \$5371 \$6233 VDD VSS \$7359 AND3_X1
X$12412 \$7094 \$7286 \$7233 VDD VSS \$7234 HA_X1
X$12416 \$7235 VSS VDD \$7451 INV_X1
X$12417 \$7095 \$7235 VDD VSS \$7517 XNOR2_X1
X$12421 VSS \$6738 \$7443 \$7238 \$6443 \$7237 VDD FA_X1
X$12423 \$7027 VSS VDD \$7364 INV_X1
X$12428 VSS \$6744 \$7424 \$7416 \$6742 \$7367 VDD FA_X1
X$12430 \$7096 VSS VDD \$7408 INV_X1
X$12433 \$7135 VSS VDD \$7098 INV_X1
X$12434 \$6944 \$6945 \$7100 VDD VSS \$7099 HA_X1
X$12436 \$7128 \$7100 VSS VDD \$7102 NAND2_X1
X$12437 \$7102 VSS VDD \$7103 INV_X1
X$12438 \$7103 \$7124 VSS VDD \$7242 NAND2_X1
X$12442 \$6764 \$7113 VSS VDD \$7374 NAND2_X1
X$12443 \$6950 \$6462 VSS VDD \$7113 NAND2_X1
X$12444 \$6462 \$6952 VDD VSS \$7108 XNOR2_X1
X$12446 VSS \$7105 \$I72940 \$6953 \$7108 \$5920 VDD DFFR_X1
X$12455 \$7137 VSS VDD \$7239 INV_X1
X$12458 \$7099 \$7128 VSS VDD \$7261 NAND2_X1
X$12459 \$7099 \$7100 \$7009 VSS \$7525 VDD AOI21_X1
X$12460 \$7261 \$7242 \$7370 \$7243 VSS VDD \$7644 NAND4_X1
X$12463 \$7254 \$7100 VSS VDD \$7255 XOR2_X1
X$12467 VSS \$7105 \$I72414 \$7372 \$7249 \$5920 VDD DFFR_X1
X$12484 VSS \$7065 \$I72971 \$7323 \$7384 \$4645 VDD DFFR_X1
X$12485 VSS \$7065 \$I72932 \$7392 \$7323 \$4645 VDD DFFR_X1
X$12488 VSS \$7065 \$I72955 \$7396 \$7392 \$4645 VDD DFFR_X1
X$12491 VSS \$7324 \$I72655 \$6163 \$7396 \$4645 VDD DFFR_X1
X$12496 \$7063 VSS VDD yout[0] BUF_X1
X$12501 \$4426 VSS VDD yout[2] BUF_X1
X$12509 \$6162 VSS VDD \$5026 INV_X1
X$12520 VSS \$7610 \$7776 \$7609 \$7661 \$7650 VDD FA_X1
X$12521 \$7649 \$6674 VSS VDD \$7610 NAND2_X1
X$12522 \$7613 \$6786 VSS VDD \$7650 NAND2_X1
X$12524 \$6674 \$7613 VDD VSS \$7614 AND2_X1
X$12525 \$6466 \$7615 VSS VDD \$7661 OR2_X1
X$12530 \$7824 VSS VDD \$7616 INV_X1
X$12531 \$7731 \$7616 \$7826 VDD VSS \$7798 HA_X1
X$12534 \$7670 VSS VDD \$7324 CLKBUF_X3
X$12535 VSS \$7324 \$I72744 \$8352 \$7674 \$7479 VDD DFFR_X1
X$12538 \$7481 \$7480 VDD VSS \$7617 XNOR2_X1
X$12543 \$4070 VSS VDD yout[4] BUF_X1
X$12546 \$4033 VSS VDD yout[5] BUF_X1
X$12550 \$4225 VSS VDD yout[7] BUF_X1
X$12551 \$4038 VSS VDD yout[6] BUF_X1
X$12555 \$7727 \$7809 VDD VSS \$7879 XNOR2_X1
X$12557 VSS \$7609 \$7727 \$7887 \$7811 \$7812 VDD FA_X1
X$12558 \$7892 VSS VDD \$7812 INV_X1
X$12559 VSS \$7814 \$7892 \$7894 \$7783 \$7614 VDD FA_X1
X$12560 \$7615 \$5973 VSS VDD \$7783 NOR2_X1
X$12562 \$7615 \$5674 VSS VDD \$7898 NOR2_X1
X$12564 \$7821 VSS VDD \$7820 INV_X1
X$12565 \$7649 \$5973 VSS VDD \$7821 NAND2_X1
X$12570 \$6162 \$8076 \$7824 VSS VDD \$7914 NOR3_X1
X$12572 \$7914 \$7826 \$7916 VDD VSS \$7732 HA_X1
X$12573 \$7916 \$8254 \$5026 VSS VDD \$7920 NAND3_X1
X$12575 \$7920 VSS VDD \$7799 INV_X1
X$12578 \$7828 \$7732 VSS VDD \$7733 NAND2_X1
X$12579 \$7799 \$7829 \$7828 VDD VSS \$7926 HA_X1
X$12581 \$7926 VSS VDD \$7925 INV_X1
X$12582 \$7734 \$7925 \$7733 VSS \$7830 VDD AOI21_X1
X$12584 \$7735 VSS VDD \$7734 INV_X1
X$12586 VSS \$7324 \$I72537 \$8196 \$7930 \$7479 VDD DFFR_X1
X$12590 VSS \$7324 \$I72538 \$8260 \$7617 \$7479 VDD DFFR_X1
X$12592 \$7553 \$7482 \$7618 VSS \$7678 VDD AOI21_X1
X$12594 \$7553 \$7482 \$7694 VSS \$7481 VDD AOI21_X1
X$12595 \$7618 \$7482 VSS VDD \$7935 XOR2_X1
X$12599 \$7619 \$7485 VDD VSS \$8204 XNOR2_X1
X$12600 \$7485 VSS VDD \$7695 INV_X1
X$12601 \$7695 \$7619 \$7620 VDD \$7694 VSS OAI21_X1
X$12603 \$7487 VSS VDD \$7620 INV_X1
X$12606 \$7489 \$7485 VSS VDD \$7621 NAND2_X1
X$12607 \$7621 \$7703 \$7620 \$7803 VSS VDD \$7618 NAND4_X1
X$12608 \$7485 \$7560 VSS VDD \$7623 NAND2_X1
X$12609 \$7489 \$7560 \$7705 VSS \$7619 VDD AOI21_X1
X$12610 \$7623 VSS VDD \$7738 INV_X1
X$12614 \$7626 \$7741 VSS VDD \$7705 NAND2_X1
X$12615 \$7624 VSS VDD \$7625 INV_X1
X$12616 \$7627 \$7563 \$7624 VDD VSS \$7708 HA_X1
X$12617 \$7708 VSS VDD \$7626 INV_X1
X$12618 \$7434 \$7566 \$7742 VDD VSS \$7745 HA_X1
X$12628 \$7938 \$7560 VSS VDD \$8207 XOR2_X1
X$12630 \$7738 \$7739 VSS VDD \$7703 NAND2_X1
X$12633 \$7738 \$7624 \$7742 \$7743 VSS VDD \$7803 NAND4_X1
X$12634 \$7624 \$8097 VSS VDD \$7741 NAND2_X1
X$12635 \$7794 \$7625 \$7626 VDD \$7739 VSS OAI21_X1
X$12636 \$7625 \$7831 \$7626 VDD \$7938 VSS OAI21_X1
X$12637 \$7745 \$7742 \$7743 VSS \$7831 VDD AOI21_X1
X$12639 \$7745 VSS VDD \$7794 INV_X1
X$12643 \$7628 \$7711 \$7832 VDD VSS \$7746 HA_X1
X$12645 \$7494 VSS VDD \$7964 INV_X1
X$12650 \$7746 VSS VDD \$7834 INV_X1
X$12652 \$7747 VSS VDD \$7959 INV_X1
X$12655 VSS \$7791 \$7747 \$7965 \$7964 \$7629 VDD FA_X1
X$12656 \$7965 VSS VDD \$7836 INV_X1
X$12658 \$7448 VSS VDD \$7791 INV_X1
X$12662 \$6175 \$6436 \$7630 VDD \$7838 VSS OAI21_X1
X$12663 \$6436 \$5861 VSS VDD \$7632 OR2_X1
X$12667 VSS \$7632 \$7837 \$7840 \$7498 \$7630 VDD FA_X1
X$12669 \$7499 VSS VDD \$7633 INV_X1
X$12673 VSS \$7635 \$7634 \$8230 \$7726 \$7583 VDD FA_X1
X$12676 \$5181 \$6436 VSS VDD \$7789 NOR2_X1
X$12678 \$7634 VSS VDD \$7975 INV_X1
X$12681 \$5579 \$6436 VSS VDD \$7726 NOR2_X1
X$12685 VSS \$7636 \$7979 \$7589 \$7713 \$7592 VDD FA_X1
X$12686 \$5861 \$6562 VSS VDD \$7636 NAND2_X1
X$12688 \$5181 \$6562 VSS VDD \$7638 NAND2_X1
X$12689 \$7638 VSS VDD \$7786 INV_X1
X$12691 \$6175 \$6562 VSS VDD \$7841 NAND2_X1
X$12692 \$7979 VSS VDD \$7787 INV_X1
X$12693 \$7841 VSS VDD \$7978 INV_X1
X$12694 \$7592 VSS VDD \$7842 INV_X1
X$12697 \$7713 VSS VDD \$7843 INV_X1
X$12701 VSS \$7785 \$8442 \$7986 \$7786 \$7843 VDD FA_X1
X$12702 \$7508 VSS VDD \$7785 INV_X1
X$12705 VSS \$6928 \$8621 \$8127 \$7220 \$7750 VDD FA_X1
X$12708 \$7701 VSS VDD \$7751 INV_X1
X$12711 \$7699 VSS VDD \$7847 INV_X1
X$12714 \$7986 VSS VDD \$7750 INV_X1
X$12715 \$6175 \$5721 VSS VDD \$8236 NAND2_X1
X$12717 \$6175 \$6233 VSS VDD \$7844 NAND2_X1
X$12720 \$5861 \$5721 VSS VDD \$7994 NAND2_X1
X$12723 \$5861 \$6233 VSS VDD \$7846 NAND2_X1
X$12724 \$5181 \$5721 VSS VDD \$7756 NAND2_X1
X$12725 \$7756 VSS VDD \$7848 INV_X1
X$12736 VSS \$3231 \$I72399 \$3291 \$3828 \$1003 VDD DFFR_X1
X$12742 \$3232 VSS VDD CLKBUF_X1
X$12743 \$1545 VSS VDD \$3232 CLKBUF_X3
X$12746 VSS \$3232 \$I72635 \$3424 \$3466 \$1003 VDD DFFR_X1
X$12748 VSS \$3668 \$I72641 \$3556 \$3468 \$1003 VDD DFFR_X1
X$12750 VSS \$3471 \$I72967 \$3558 \$3557 \$1914 VDD DFFR_X1
X$12756 VSS \$3668 \$I72483 \$3557 \$3556 \$1003 VDD DFFR_X1
X$12759 VSS \$3471 \$I72336 \$3559 \$3558 \$1914 VDD DFFR_X1
X$12760 VSS \$2981 \$I72353 \$3609 \$3559 \$2883 VDD DFFR_X1
X$12761 VSS \$2981 \$I72528 \$3614 \$3609 \$2883 VDD DFFR_X1
X$12762 \$85 VSS VDD \$2981 CLKBUF_X3
X$12770 VSS \$2981 \$I72560 \$3619 \$3613 \$2883 VDD DFFR_X1
X$12772 VSS \$4028 \$I72659 \$3325 \$3488 \$2883 VDD DFFR_X1
X$12773 VSS \$3960 \$I72825 \$3488 \$3619 \$2883 VDD DFFR_X1
X$12774 VSS \$2982 \$I72613 \$3754 \$3490 \$1445 VDD DFFR_X1
X$12781 \$2130 VSS VDD \$4173 BUF_X1
X$12787 \$3500 \$3565 \$2641 VDD VSS \$3501 HA_X1
X$12789 \$3501 VSS VDD \$3430 INV_X1
X$12793 \$3245 \$3246 VSS \$3244 VDD NAND2_X4
X$12796 \$3520 \$3431 VSS VDD \$3514 NAND2_X1
X$12797 \$2133 \$3250 \$3528 VSS VDD \$3523 NAND3_X1
X$12798 \$3253 \$2975 \$3523 VSS VDD \$3437 NAND3_X1
X$12799 \$3435 \$3436 \$3520 VDD \$3528 VSS OAI21_X1
X$12800 \$3433 VSS VDD \$3436 INV_X1
X$12806 \$3873 VSS VDD \$3241 INV_X1
X$12807 \$3564 VSS VDD \$3565 INV_X1
X$12811 \$27 \$3672 \$3637 VSS VDD \$2130 NOR3_X1
X$12812 \$3566 VSS VDD \$3637 INV_X1
X$12817 \$3647 VSS VDD \$3567 INV_X1
X$12818 \$3568 \$3515 \$3675 VDD VSS \$3647 HA_X1
X$12820 \$3514 \$3250 VDD VSS \$3570 XNOR2_X1
X$12821 \$3572 \$3433 VDD VSS \$3571 XNOR2_X1
X$12822 \$3433 \$3572 VSS VDD \$3431 NAND2_X1
X$12824 \$3435 \$3761 VSS VDD \$3572 NAND2_X1
X$12826 \$3573 \$3433 \$3250 \$2133 VDD VSS \$3651 AND4_X1
X$12829 \$3664 VSS VDD \$3435 INV_X1
X$12830 \$3655 \$3439 \$3573 VDD VSS \$3664 HA_X1
X$12832 \$3440 VSS VDD \$3439 INV_X1
X$12837 \$3437 VSS VDD \$3679 INV_X1
X$12838 \$3652 VSS VDD \$3655 INV_X1
X$12839 VSS \$3544 \$3652 \$3920 \$3656 \$3258 VDD FA_X1
X$12841 \$3154 VSS VDD \$3656 INV_X1
X$12843 \$3543 VSS VDD \$3544 INV_X1
X$12845 VSS \$3551 \$3543 \$3574 \$3441 \$3545 VDD FA_X1
X$12851 \$3574 VSS VDD \$3758 INV_X1
X$12853 \$3001 \$3261 \$3550 VDD VSS \$3551 HA_X1
X$12855 \$3550 VSS VDD \$3442 INV_X1
X$12857 \$3263 VSS VDD \$3576 INV_X1
X$12861 \$3262 VSS VDD \$3575 INV_X1
X$12863 VSS \$3644 \$3681 \$3753 \$3442 \$3576 VDD FA_X1
X$12865 \$3548 VSS VDD \$3644 INV_X1
X$12869 VSS \$3268 \$3682 \$3443 \$3216 \$3444 VDD FA_X1
X$12874 \$3443 VSS VDD \$3750 INV_X1
X$12876 \$3685 VSS VDD \$I74143 INV_X4
X$12877 \$3640 VSS VDD \$3577 INV_X1
X$12879 \$3532 VSS VDD \$3539 INV_X1
X$12880 VSS \$3270 \$3640 \$3638 \$3271 \$3539 VDD FA_X1
X$12882 \$3638 VSS VDD \$3747 INV_X1
X$12885 \$3537 \$3273 \$3446 VDD VSS \$3532 HA_X1
X$12889 \$3633 \$3446 \$3686 VDD VSS \$3634 HA_X1
X$12890 \$3212 VSS VDD \$3742 INV_X1
X$12896 \$3447 \$3630 VDD VSS \$3950 XNOR2_X1
X$12897 VSS \$3735 \$3630 \$3629 \$3447 \$3628 VDD FA_X1
X$12899 VSS \$3449 \$3380 \$3448 \$3447 \$3450 VDD FA_X1
X$12905 VSS \$3579 \$3450 \$3512 \$3578 \$3624 VDD FA_X1
X$12907 \$3348 VSS VDD \$3578 INV_X1
X$12914 VSS \$3452 \$3364 \$3506 \$3507 \$3348 VDD FA_X1
X$12919 \$3305 VSS VDD \$I74122 INV_X2
X$12920 \$1762 VSS VDD \$3305 CLKBUF_X3
X$12922 \$3014 \$1357 VSS VDD \$3280 NAND2_X1
X$12923 VSS \$3495 \$3499 \$2941 \$3498 \$3455 VDD FA_X1
X$12927 VSS \$3285 \$3496 \$3478 \$3481 \$3585 VDD FA_X1
X$12928 \$3496 VSS VDD \$3495 INV_X1
X$12931 \$1680 \$1578 VSS VDD \$3584 NAND2_X1
X$12932 \$3584 VSS VDD \$3585 INV_X1
X$12934 \$1583 \$3065 VSS VDD \$3481 NOR2_X1
X$12938 \$3020 VSS VDD CLKBUF_X1
X$12941 VSS \$3020 \$I72352 \$1580 \$3850 \$2922 VDD DFFR_X1
X$12944 VSS \$3605 \$I72411 \$1357 \$4112 \$2922 VDD DFFR_X1
X$12947 VSS \$3456 \$I72620 \$1476 \$3589 \$2922 VDD DFFR_X1
X$12949 VSS \$3456 \$I72933 \$1583 \$3592 \$2922 VDD DFFR_X1
X$12950 VSS \$3456 \$I72776 \$3458 \$4108 \$2922 VDD DFFR_X1
X$12962 VSS \$3456 \$I72432 \$3592 \$3709 \$2922 VDD DFFR_X1
X$12963 \$3305 VSS VDD \$3456 CLKBUF_X3
X$12982 VSS \$3471 \$I72907 \$4261 \$4260 \$1914 VDD DFFR_X1
X$12983 VSS \$3471 \$I72808 \$4296 \$4261 \$1914 VDD DFFR_X1
X$12984 VSS \$4262 \$I72632 \$4300 \$4296 \$2883 VDD DFFR_X1
X$12996 VSS \$4388 \$I72255 \$4351 \$275 \$1914 VDD DFFR_X1
X$12999 VSS \$3471 \$I72563 \$4353 \$775 \$1914 VDD DFFR_X1
X$13003 VSS \$4262 \$I72361 \$4357 \$4399 \$2883 VDD DFFR_X1
X$13006 VSS \$4262 \$I72543 \$4409 \$4447 \$2883 VDD DFFR_X1
X$13008 VSS \$4262 \$I72855 \$4305 \$4300 \$2883 VDD DFFR_X1
X$13010 VSS \$4262 \$I72384 \$4411 \$4409 \$2883 VDD DFFR_X1
X$13011 VSS \$4362 \$I72547 \$4359 \$4411 \$2883 VDD DFFR_X1
X$13012 VSS \$4028 \$3500 \$I65832 \$4305 \$2883 VDD DFFR_X1
X$13017 \$4265 \$4077 VSS VDD \$4222 NOR2_X1
X$13018 \$4077 \$4078 VSS VDD \$4312 NOR2_X1
X$13020 \$4077 \$3246 VSS VDD \$4225 NOR2_X1
X$13022 VSS \$4028 \$I72454 \$4418 \$4359 \$2883 VDD DFFR_X1
X$13024 \$3965 VSS VDD \$I74117 INV_X2
X$13025 \$1762 VSS VDD \$3965 CLKBUF_X3
X$13026 VSS \$4362 \$I72477 \$4429 \$4418 \$3256 VDD DFFR_X1
X$13030 \$3878 \$3256 VDD VSS \$4426 AND2_X1
X$13033 \$4429 VSS VDD \$3146 INV_X1
X$13035 \$3785 VSS VDD \$I74139 INV_X2
X$13036 \$3965 VSS VDD \$3785 CLKBUF_X3
X$13037 \$4265 VSS VDD \$4080 INV_X1
X$13040 \$4363 \$3256 VSS VDD \$4358 NAND2_X1
X$13043 VSS \$3785 \$I72360 \$4434 \$1442 \$3256 VDD DFFR_X1
X$13044 \$4176 VSS VDD \$4081 INV_X1
X$13047 \$4363 VSS VDD \$4177 INV_X1
X$13050 \$4178 VSS VDD \$4083 INV_X1
X$13052 \$4237 VSS VDD \$4180 INV_X1
X$13053 \$4331 \$4179 VSS VDD \$4165 NAND2_X1
X$13054 \$4182 \$4268 \$4237 VDD VSS \$4178 HA_X1
X$13055 \$4156 \$4085 VDD VSS \$3878 XNOR2_X1
X$13056 \$4268 \$4182 \$4337 VDD VSS \$I70300 HA_X1
X$13057 VSS \$4184 \$4156 \$4265 \$4270 \$4515 VDD FA_X1
X$13058 \$4183 VSS VDD \$4184 INV_X1
X$13059 \$4187 \$4085 VSS VDD \$4248 NAND2_X1
X$13061 \$4270 VSS VDD \$4186 INV_X1
X$13063 \$4271 VSS VDD \$4086 INV_X1
X$13066 VSS \$4188 \$I72781 \$4062 \$5316 \$3256 VDD DFFR_X1
X$13075 \$4364 \$4405 \$4363 VDD VSS \$4183 HA_X1
X$13077 \$4519 \$4421 \$4085 VDD VSS \$4271 HA_X1
X$13079 \$4233 VSS VDD \$4421 INV_X1
X$13080 \$4188 VSS VDD \$I74123 INV_X2
X$13081 VSS \$4188 \$I72267 \$6137 \$47 \$3256 VDD DFFR_X1
X$13082 \$4341 VSS VDD \$4405 INV_X1
X$13085 \$4091 \$3978 VDD VSS \$4270 XNOR2_X1
X$13087 \$4273 \$3980 VDD VSS \$4341 XNOR2_X1
X$13092 \$3980 \$4273 VSS VDD \$4190 NAND2_X1
X$13096 VSS \$4316 \$I72837 \$4220 \$4309 \$4191 VDD DFFR_X1
X$13097 VSS \$4517 \$I72909 \$3415 \$4513 \$4191 VDD DFFR_X1
X$13098 VSS \$4316 \$I72894 \$4124 \$4311 \$4191 VDD DFFR_X1
X$13100 VSS \$4276 \$I72747 \$1518 \$4308 \$4191 VDD DFFR_X1
X$13101 VSS \$4276 \$I72914 \$4192 \$4863 \$4191 VDD DFFR_X1
X$13107 \$3685 VSS VDD \$4316 CLKBUF_X3
X$13118 VSS \$4276 \$I72583 \$4397 \$4367 \$2922 VDD DFFR_X1
X$13119 VSS \$4119 \$I72954 \$3014 \$4397 \$2922 VDD DFFR_X1
X$13127 VSS \$4097 \$I72427 \$1855 \$4490 \$2922 VDD DFFR_X1
X$13129 VSS \$4097 \$I72688 \$1578 \$4557 \$2922 VDD DFFR_X1
X$13136 VSS \$4371 \$I72467 \$4372 \$4392 \$2922 VDD DFFR_X1
X$13137 VSS \$3605 \$I72930 \$1467 \$4278 \$2922 VDD DFFR_X1
X$13144 VSS \$3824 \$I72581 \$3989 \$4374 \$2922 VDD DFFR_X1
X$13147 \$3305 VSS VDD \$3824 CLKBUF_X3
X$13149 \$4281 \$4280 VSS VDD \$4283 NAND2_X1
X$13152 \$4283 VSS VDD \$4197 INV_X1
X$13154 \$4279 \$4100 VSS VDD \$4285 NAND2_X1
X$13156 \$4285 VSS VDD \$4290 INV_X1
X$13157 \$4290 \$4197 \$4200 VDD VSS \$4469 HA_X1
X$13167 \$3294 \$3996 \$4198 VDD VSS \$4382 AND3_X1
X$13169 \$4376 \$4386 VSS VDD \$4379 NAND2_X1
X$13170 \$4382 \$4377 \$4376 VDD VSS \$4383 HA_X1
X$13171 \$4383 VSS VDD \$4385 INV_X1
X$13173 \$4385 \$4379 VSS VDD \$4378 NAND2_X1
X$13191 VSS \$4778 \$I72764 \$4773 \$4888 \$1914 VDD DFFR_X1
X$13195 VSS \$4778 \$I72769 \$4782 \$4901 \$1914 VDD DFFR_X1
X$13196 \$1762 VSS VDD \$4488 CLKBUF_X3
X$13200 \$4744 \$4742 VSS VDD \$4842 NAND2_X1
X$13201 \$4742 \$4743 VDD VSS \$4541 XNOR2_X1
X$13202 \$4744 VSS VDD \$4743 INV_X1
X$13204 \$4744 \$4745 VSS VDD \$4919 NAND2_X1
X$13208 VSS \$5064 \$I72374 \$4975 \$5105 \$1914 VDD DFFR_X1
X$13215 VSS \$5064 \$I72400 \$4888 \$4891 \$1914 VDD DFFR_X1
X$13218 \$4778 VSS VDD \$I55556 INV_X1
X$13219 \$4488 VSS VDD \$4778 CLKBUF_X3
X$13220 VSS \$4778 \$I72296 \$4901 \$4895 \$4645 VDD DFFR_X1
X$13224 \$3137 \$4841 \$4839 VDD VSS \$5079 HA_X1
X$13227 \$4843 \$4842 VSS VDD \$4911 NAND2_X1
X$13230 \$4746 \$4743 \$4843 \$4919 \$4844 VDD VSS \$4916 OAI221_X1
X$13231 \$4933 \$4643 VDD VSS \$4709 AND2_X1
X$13232 \$4642 VSS VDD \$4843 INV_X1
X$13236 \$4844 \$4745 VDD VSS \$4922 XNOR2_X1
X$13237 \$3238 \$4924 \$4745 VDD VSS \$4926 HA_X1
X$13238 \$4749 \$4745 VSS VDD \$4644 NAND2_X1
X$13239 \$4644 \$4746 \$4747 VSS VDD \$4742 NAND3_X1
X$13240 \$4745 \$4647 \$4720 VSS VDD \$4747 NAND3_X1
X$13242 \$4926 VSS VDD \$4746 INV_X1
X$13244 VSS \$4929 \$4844 \$4983 \$4930 \$4646 VDD FA_X1
X$13245 \$4720 VSS VDD \$4929 INV_X1
X$13249 \$4930 VSS VDD \$4648 INV_X1
X$13252 VSS \$4937 \$I72666 \$4750 \$4809 \$4645 VDD DFFR_X1
X$13253 \$4933 \$4750 VDD VSS \$4714 AND2_X1
X$13256 VSS \$4937 \$I72983 \$4811 \$4936 \$3256 VDD DFFR_X1
X$13257 \$4645 VSS VDD \$3256 BUF_X2
X$13261 VSS \$4848 \$I72797 \$5399 \$44 \$3256 VDD DFFR_X1
X$13265 \$4452 VSS VDD \$I56463 INV_X1
X$13268 VSS \$4957 \$I72675 \$4827 \$2848 \$4657 VDD DFFR_X1
X$13270 VSS \$4957 \$I72651 \$4752 \$4827 \$4657 VDD DFFR_X1
X$13272 \$3256 VSS VDD \$4657 BUF_X2
X$13279 VSS \$4937 \$I72315 \$4846 \$4650 \$3256 VDD DFFR_X1
X$13280 VSS \$4848 \$I72312 \$4847 \$4846 \$5084 VDD DFFR_X1
X$13285 \$3965 VSS VDD \$4848 CLKBUF_X3
X$13286 \$4848 VSS VDD \$I55596 INV_X1
X$13288 VSS \$4848 \$I72405 \$4988 \$4616 \$3256 VDD DFFR_X1
X$13291 VSS \$4452 \$I72329 \$5724 \$171 \$3256 VDD DFFR_X1
X$13297 VSS \$4853 \$I72308 \$4855 \$4847 \$4191 VDD DFFR_X1
X$13298 VSS \$5089 \$I72297 \$4856 \$4855 \$4191 VDD DFFR_X1
X$13300 VSS \$4857 \$I72279 \$4966 \$4856 \$4191 VDD DFFR_X1
X$13302 VSS \$5089 \$I72681 \$4754 \$4661 \$4191 VDD DFFR_X1
X$13304 VSS \$4857 \$I72569 \$4940 \$4966 \$4191 VDD DFFR_X1
X$13305 \$4657 VSS VDD \$4191 BUF_X2
X$13308 VSS \$4857 \$I72977 \$4510 \$4831 \$4191 VDD DFFR_X1
X$13311 VSS \$4517 \$I72842 \$3687 \$4826 \$4191 VDD DFFR_X1
X$13312 VSS \$4861 \$I72915 \$4823 \$4825 \$4657 VDD DFFR_X1
X$13315 VSS \$4861 \$I72990 \$4667 \$4822 \$4191 VDD DFFR_X1
X$13318 VSS \$4995 \$I72972 \$4670 \$4821 \$4191 VDD DFFR_X1
X$13322 VSS \$4995 \$I72790 \$4815 \$4754 \$4460 VDD DFFR_X1
X$13327 VSS \$4857 \$I72579 \$4729 \$5382 \$4191 VDD DFFR_X1
X$13328 VSS \$4857 \$I72306 \$3008 \$4858 \$4191 VDD DFFR_X1
X$13335 VSS \$4861 \$I72544 \$4863 \$4946 \$4191 VDD DFFR_X1
X$13341 VSS \$4995 \$I72380 \$4867 \$4865 \$4460 VDD DFFR_X1
X$13343 VSS \$4914 \$I72693 \$4760 \$4757 \$4460 VDD DFFR_X1
X$13344 VSS \$4914 \$I72704 \$4757 \$4815 \$4460 VDD DFFR_X1
X$13345 VSS \$4371 \$I72670 \$4100 \$4760 \$4460 VDD DFFR_X1
X$13347 \$4759 \$4279 VSS VDD \$4793 NAND2_X1
X$13348 \$4599 \$4281 VSS VDD \$4763 NAND2_X1
X$13350 \$4763 VSS VDD \$4791 INV_X1
X$13351 \$4793 VSS VDD \$4789 INV_X1
X$13352 \$4789 \$4791 \$4774 VDD VSS \$5012 HA_X1
X$13353 \$4280 \$4392 VSS VDD \$4764 NAND2_X1
X$13359 \$4759 \$4281 VSS VDD \$4873 NAND2_X1
X$13360 \$4873 VSS VDD \$4874 INV_X1
X$13364 VSS \$4772 \$5011 \$4886 \$4893 \$4878 VDD FA_X1
X$13365 \$4764 VSS VDD \$4772 INV_X1
X$13366 \$4676 VSS VDD \$4893 INV_X1
X$13367 \$4678 VSS VDD \$4878 INV_X1
X$13368 \$4774 VSS VDD \$4771 INV_X1
X$13372 VSS \$4771 \$4884 \$4769 \$4765 \$4686 VDD FA_X1
X$13374 \$4769 VSS VDD \$4766 INV_X1
X$13376 \$4882 VSS VDD \$4768 INV_X1
X$13385 \$4884 VSS VDD \$5111 INV_X1
X$13386 \$4766 \$4886 \$4882 VDD VSS \$5104 HA_X1
X$13390 \$4767 VSS VDD \$4881 INV_X1
X$13412 VSS \$1826 \$I72804 \$2488 \$2418 \$1003 VDD DFFR_X1
X$13417 VSS \$2725 \$I72275 \$2777 \$2488 \$1003 VDD DFFR_X1
X$13419 \$1914 VSS VDD \$1003 BUF_X2
X$13424 VSS \$2274 \$I72897 \$2492 \$2427 \$1003 VDD DFFR_X1
X$13426 VSS \$2274 \$I72833 \$2496 \$2435 \$1914 VDD DFFR_X1
X$13431 \$2500 \$2395 \$2396 VDD \$2122 VSS OAI21_X1
X$13432 \$2453 \$2395 \$2396 VDD \$2229 VSS OAI21_X1
X$13434 \$2503 VSS VDD \$2453 INV_X1
X$13437 \$2274 VSS VDD CLKBUF_X1
X$13438 \$1545 VSS VDD \$2274 CLKBUF_X3
X$13440 VSS \$2274 \$I72266 \$2435 \$2492 \$1003 VDD DFFR_X1
X$13443 VSS \$1916 \$I72433 \$2635 \$2496 \$1914 VDD DFFR_X1
X$13444 VSS \$1916 \$I72496 \$2636 \$2498 \$1914 VDD DFFR_X1
X$13446 \$1711 \$1925 VDD VSS \$4399 XNOR2_X1
X$13449 \$2681 VSS VDD \$2559 INV_X1
X$13451 \$2229 \$2559 \$2637 VSS \$1711 VDD AOI21_X1
X$13452 \$2501 VSS VDD \$2395 INV_X1
X$13453 \$2501 \$2565 VSS VDD \$2681 NAND2_X1
X$13454 \$2504 \$2397 \$2565 VDD VSS \$2503 HA_X1
X$13456 \$2566 VSS VDD \$2396 INV_X1
X$13458 \$2505 VSS VDD \$2504 INV_X1
X$13461 \$2457 \$2230 \$2501 VDD VSS \$2566 HA_X1
X$13462 VSS \$2459 \$2457 \$2397 \$2185 \$2398 VDD FA_X1
X$13463 \$2463 \$2470 \$2399 VDD VSS \$2459 HA_X1
X$13468 \$2399 VSS VDD \$2796 INV_X1
X$13471 \$2231 VSS VDD \$2463 INV_X1
X$13475 \$2468 \$2233 \$2400 VDD VSS \$2574 HA_X1
X$13477 \$2235 \$2236 \$2640 VDD VSS \$2468 HA_X1
X$13480 \$2574 VSS VDD \$2691 INV_X1
X$13482 \$2482 \$2407 VSS VDD \$2238 OR2_X1
X$13483 VSS \$1934 \$1649 \$2402 \$2577 \$1445 VDD DFFR_X1
X$13484 \$2403 \$2404 VSS VDD \$2336 OR2_X1
X$13485 \$27 \$2404 \$2403 VSS \$2480 VDD AOI21_X1
X$13486 \$27 \$2407 \$2482 VSS \$2341 VDD AOI21_X1
X$13495 \$2588 \$2407 \$2642 VSS \$2403 VDD AOI21_X1
X$13499 VSS \$1934 \$I72789 \$2577 \$2385 \$1445 VDD DFFR_X1
X$13504 \$2095 \$643 VSS VDD \$2511 NAND2_X1
X$13505 \$2382 \$938 VSS VDD \$2616 NAND2_X1
X$13508 VSS \$2249 \$2621 \$2478 \$2474 \$2387 VDD FA_X1
X$13509 \$817 \$2107 VSS VDD \$2516 NAND2_X1
X$13511 VSS \$2242 \$I72508 \$2648 \$2509 \$1445 VDD DFFR_X1
X$13514 VSS \$2371 \$2651 \$2606 \$2362 \$2607 VDD FA_X1
X$13515 \$2606 VSS VDD \$2720 INV_X1
X$13519 VSS \$2616 \$2607 \$2614 \$2618 \$2511 VDD FA_X1
X$13520 \$2614 VSS VDD \$2715 INV_X1
X$13522 \$1783 \$1315 VSS VDD \$2618 NAND2_X1
X$13523 \$2621 VSS VDD \$2716 INV_X1
X$13526 VSS \$2631 \$2718 \$2709 \$2478 \$2707 VDD FA_X1
X$13527 \$2382 \$1315 VSS VDD \$2653 NAND2_X1
X$13528 \$2516 VSS VDD \$2702 INV_X1
X$13529 \$2517 \$2702 \$3001 VDD VSS \$2519 HA_X1
X$13530 VSS \$2472 \$I72678 \$2385 \$2518 \$175 VDD DFFR_X1
X$13531 \$608 \$2412 VSS VDD \$2474 NAND2_X1
X$13532 \$2461 VSS VDD \$2382 INV_X1
X$13533 \$831 \$2349 VSS VDD \$2520 NAND2_X1
X$13535 VSS \$2472 \$2355 \$2518 \$2451 \$175 VDD DFFR_X1
X$13536 \$2245 \$2107 VSS VDD \$2255 NAND2_X1
X$13537 \$2255 VSS VDD \$2526 INV_X1
X$13539 \$2520 VSS VDD \$2517 INV_X1
X$13540 \$2519 VSS VDD \$2631 INV_X1
X$13543 \$2382 \$1655 VSS VDD \$2656 NAND2_X1
X$13545 VSS \$2472 \$2868 \$2095 \$2695 \$175 VDD DFFR_X1
X$13546 \$2472 VSS VDD CLKBUF_X1
X$13549 \$2518 \$1655 VSS VDD \$2524 NAND2_X1
X$13550 \$2524 VSS VDD \$2693 INV_X1
X$13551 \$2693 \$2526 \$2659 VDD VSS \$3633 HA_X1
X$13553 \$2412 \$2355 \$2255 VSS VDD \$2660 NOR3_X1
X$13554 VSS \$2257 \$I72830 \$831 \$3008 \$175 VDD DFFR_X1
X$13568 VSS \$4438 \$I72771 \$4475 \$4439 \$1914 VDD DFFR_X1
X$13569 VSS \$4438 \$I72713 \$4477 \$4475 \$1914 VDD DFFR_X1
X$13571 VSS \$4388 \$I72775 \$4444 \$4477 \$1914 VDD DFFR_X1
X$13572 VSS \$4388 \$I72946 \$4260 \$4444 \$1914 VDD DFFR_X1
X$13578 VSS \$4438 \$I72373 \$4581 \$4571 \$1914 VDD DFFR_X1
X$13579 VSS \$4438 \$I72350 \$4439 \$4581 \$1914 VDD DFFR_X1
X$13583 \$4388 VSS VDD \$I55449 INV_X1
X$13584 \$4488 VSS VDD \$4388 CLKBUF_X3
X$13585 VSS \$4388 \$I72527 \$4537 \$4536 \$1914 VDD DFFR_X1
X$13586 VSS \$4388 \$I72357 \$4484 \$4537 \$1914 VDD DFFR_X1
X$13588 VSS \$4262 \$I72425 \$4539 \$2119 \$2883 VDD DFFR_X1
X$13589 VSS \$4538 \$I72619 \$4447 \$4484 \$2883 VDD DFFR_X1
X$13591 \$4488 VSS VDD \$4262 CLKBUF_X3
X$13595 \$4362 VSS VDD \$I56303 INV_X1
X$13602 VSS \$4362 \$I72523 \$4721 \$1062 \$3256 VDD DFFR_X1
X$13603 VSS \$4362 \$I72865 \$4608 \$2402 \$3256 VDD DFFR_X1
X$13609 \$3965 VSS VDD \$4362 CLKBUF_X3
X$13613 VSS \$4362 \$I72592 \$4611 \$4608 \$3256 VDD DFFR_X1
X$13616 VSS \$3785 \$I72394 \$4616 \$4434 \$3256 VDD DFFR_X1
X$13617 VSS \$3785 \$I72270 \$4734 \$2896 \$3256 VDD DFFR_X1
X$13620 VSS \$4452 \$4515 \$4088 \$4512 \$3256 VDD DFFR_X1
X$13625 VSS \$4452 \$I72556 \$4632 \$2723 \$3256 VDD DFFR_X1
X$13628 \$3685 VSS VDD \$4188 CLKBUF_X3
X$13632 VSS \$4517 \$I72683 \$2388 \$4509 \$4191 VDD DFFR_X1
X$13634 VSS \$4316 \$I72919 \$4513 \$4510 \$4191 VDD DFFR_X1
X$13641 VSS \$4316 \$I72860 \$4309 \$4505 \$4191 VDD DFFR_X1
X$13649 \$4316 VSS VDD CLKBUF_X1
X$13651 VSS \$4276 \$I72923 \$4367 \$4666 \$4191 VDD DFFR_X1
X$13652 VSS \$4316 \$I72811 \$4308 \$4497 \$4191 VDD DFFR_X1
X$13657 \$4276 VSS VDD CLKBUF_X1
X$13658 \$553 VSS VDD \$4276 CLKBUF_X3
X$13666 VSS \$4119 \$I72721 \$2921 \$4493 \$2922 VDD DFFR_X1
X$13669 VSS \$4119 \$I72715 \$4490 \$4489 \$2922 VDD DFFR_X1
X$13671 \$4191 VSS VDD \$2922 BUF_X2
X$13672 \$553 VSS VDD \$4119 CLKBUF_X3
X$13675 VSS \$4097 \$I72472 \$4459 \$4868 \$4460 VDD DFFR_X1
X$13676 \$4097 VSS VDD CLKBUF_X1
X$13678 \$3305 VSS VDD \$4097 CLKBUF_X3
X$13679 VSS \$4097 \$I72692 \$4370 \$4459 \$4460 VDD DFFR_X1
X$13680 VSS \$4371 \$I72691 \$4278 \$4558 \$4460 VDD DFFR_X1
X$13687 \$4371 VSS VDD CLKBUF_X1
X$13688 \$3305 VSS VDD \$4371 CLKBUF_X3
X$13691 VSS \$4371 \$I72506 \$4374 \$4599 \$2922 VDD DFFR_X1
X$13693 VSS \$3824 \$I72772 \$1680 \$4601 \$2922 VDD DFFR_X1
X$13696 \$4470 \$4467 \$4377 VDD VSS \$4565 HA_X1
X$13708 \$3996 \$4280 VSS VDD \$4472 NAND2_X1
X$13709 \$4281 \$4100 VSS VDD \$4473 NAND2_X1
X$13710 \$4392 \$3294 VSS VDD \$4466 NAND2_X1
X$13711 \$4466 VSS VDD \$4586 INV_X1
X$13712 \$4473 VSS VDD \$4580 INV_X1
X$13715 \$4472 VSS VDD \$4587 INV_X1
X$13716 \$4586 \$4587 \$4470 VDD VSS \$4564 HA_X1
X$13718 \$4469 \$4572 \$4467 VDD VSS \$4687 HA_X1
X$13720 \$4565 VSS VDD \$4566 INV_X1
X$13758 VSS \$2725 \$I72905 \$2675 \$2777 \$1003 VDD DFFR_X1
X$13763 VSS \$2727 \$I72912 \$2728 \$2636 \$2883 VDD DFFR_X1
X$13774 VSS \$2725 \$I72274 \$2928 \$2675 \$1003 VDD DFFR_X1
X$13779 VSS \$2727 \$I72495 \$3137 \$2301 \$2883 VDD DFFR_X1
X$13782 VSS \$2727 \$I72462 \$2942 \$2728 \$2883 VDD DFFR_X1
X$13783 \$2500 \$2501 VDD VSS \$3313 XNOR2_X1
X$13786 VSS \$2505 \$2500 \$2731 \$2794 \$2638 VDD FA_X1
X$13787 \$2397 VSS VDD \$2794 INV_X1
X$13791 \$2637 VSS VDD \$2638 INV_X1
X$13793 \$2731 VSS VDD \$2885 INV_X1
X$13796 \$2800 \$2947 \$3670 VDD VSS \$2637 HA_X1
X$13798 VSS \$2798 \$2505 \$2732 \$2796 \$2691 VDD FA_X1
X$13802 \$2732 VSS VDD \$2947 INV_X1
X$13804 \$2803 VSS VDD \$2798 INV_X1
X$13810 \$2639 \$2400 \$2802 VDD VSS \$2803 HA_X1
X$13813 \$1903 \$2640 \$2735 VDD VSS \$2805 HA_X1
X$13817 \$2641 VSS VDD \$2404 INV_X1
X$13818 \$2737 \$2739 VSS VDD \$2482 NAND2_X1
X$13819 \$2737 \$2239 VSS VDD \$2642 NAND2_X1
X$13820 \$2738 \$2741 VSS VDD \$2054 NAND2_X1
X$13821 \$2738 \$2741 VSS VDD \$2644 NOR2_X1
X$13822 \$2644 VSS VDD \$2239 INV_X1
X$13824 \$27 \$2740 \$2832 VSS VDD \$376 NOR3_X1
X$13825 \$2835 VSS VDD \$2832 INV_X1
X$13829 \$2948 VSS VDD \$2799 INV_X1
X$13831 \$2799 \$2886 VSS VDD \$2800 NAND2_X1
X$13832 \$2887 \$2805 VSS VDD \$2886 NAND2_X1
X$13833 \$2806 \$2802 \$2887 VDD VSS \$2948 HA_X1
X$13834 \$2130 \$2402 \$2735 VDD VSS \$2806 AND3_X1
X$13841 \$2816 \$2738 \$2737 VDD \$2892 VSS OAI21_X1
X$13842 \$2893 VSS VDD \$2816 INV_X1
X$13843 \$2986 VSS VDD \$2737 INV_X1
X$13844 \$2958 VSS VDD \$2738 INV_X1
X$13845 \$2893 \$2740 \$2958 VDD \$2739 VSS OAI21_X1
X$13846 \$2894 VSS VDD \$2895 INV_X1
X$13847 \$2895 \$2742 VSS VDD \$2740 NOR2_X1
X$13848 \$2895 \$2742 VSS VDD \$2835 NAND2_X1
X$13851 VSS \$2242 \$I72784 \$2744 \$376 \$1445 VDD DFFR_X1
X$13853 \$2242 VSS VDD \$I56518 INV_X1
X$13854 \$85 VSS VDD \$2242 CLKBUF_X3
X$13859 VSS \$2242 \$I72260 \$2976 \$2744 \$1445 VDD DFFR_X1
X$13860 VSS \$2242 \$I72622 \$2723 \$2648 \$1445 VDD DFFR_X1
X$13863 VSS \$2849 \$2650 \$2652 \$2137 \$2651 VDD FA_X1
X$13865 VSS \$2242 \$I72474 \$2848 \$1842 \$1445 VDD DFFR_X1
X$13868 \$2135 VSS VDD \$2975 INV_X1
X$13870 \$2847 VSS VDD \$2849 INV_X1
X$13874 VSS \$2855 \$2847 \$2853 \$2246 \$2720 VDD FA_X1
X$13877 VSS \$2716 \$2855 \$2717 \$2182 \$2715 VDD FA_X1
X$13881 VSS \$2749 \$2712 \$2867 \$2747 \$2701 VDD FA_X1
X$13882 \$2867 VSS VDD \$2707 INV_X1
X$13886 \$2870 VSS VDD \$2701 INV_X1
X$13888 \$2752 \$938 VSS VDD \$2870 NAND2_X1
X$13892 \$2853 VSS VDD \$3086 INV_X1
X$13896 \$2718 VSS VDD \$3093 INV_X1
X$13897 \$2712 VSS VDD \$3097 INV_X1
X$13900 \$2095 \$1315 VSS VDD \$2897 NAND2_X1
X$13901 \$1783 \$1558 VSS VDD \$2748 NAND2_X1
X$13903 \$2748 VSS VDD \$2747 INV_X1
X$13904 \$501 \$1655 VSS VDD \$2900 NAND2_X1
X$13906 \$2653 VSS VDD \$2749 INV_X1
X$13911 VSS \$2656 \$3106 \$2901 \$2871 \$2753 VDD FA_X1
X$13912 \$1783 \$2107 VSS VDD \$2871 NAND2_X1
X$13914 \$2752 \$1558 VSS VDD \$2753 NAND2_X1
X$13917 \$463 VSS VDD \$2472 CLKBUF_X3
X$13918 \$2868 VSS VDD \$2752 INV_X1
X$13923 \$1783 \$2349 VSS VDD \$2755 NAND2_X1
X$13925 \$2755 VSS VDD \$3006 INV_X1
X$13926 \$1106 \$2107 VSS VDD \$2756 NAND2_X1
X$13928 \$2756 VSS VDD \$2904 INV_X1
X$13929 \$2903 VSS VDD \$2954 INV_X1
X$13931 \$2095 \$1655 VSS VDD \$2903 NAND2_X1
X$13935 \$2752 \$2107 VSS VDD \$3126 NAND2_X1
X$13936 \$2660 \$2659 \$2760 VDD VSS \$3163 HA_X1
X$13942 \$2760 \$2752 \$2349 VSS VDD \$3212 NAND3_X1
X$13948 VSS \$2257 \$I72817 \$2451 \$2838 \$175 VDD DFFR_X1
X$13951 \$2664 \$2662 \$2414 VSS \$2680 VDD AOI21_X1
X$13956 \$2836 \$3211 VDD VSS \$395 XNOR2_X1
X$13958 \$2761 VSS VDD \$2762 INV_X1
X$13959 \$2762 \$2680 \$2763 VDD \$2836 VSS OAI21_X1
X$13961 \$2908 VSS VDD \$2763 INV_X1
X$13964 \$2824 \$2909 \$2662 VDD VSS \$2664 HA_X1
X$13966 \$2664 VSS VDD \$2663 INV_X1
X$13968 \$2910 VSS VDD \$2824 INV_X1
X$13970 \$2911 VSS VDD \$2665 INV_X1
X$13976 VSS \$2818 \$2578 \$2666 \$2764 \$2765 VDD FA_X1
X$13979 \$2823 VSS VDD \$2765 INV_X1
X$13981 VSS \$2767 \$2823 \$2768 \$2531 \$2912 VDD FA_X1
X$13983 VSS \$2769 \$2818 \$2676 \$2941 \$2817 VDD FA_X1
X$13987 \$1680 \$1357 VSS VDD \$2670 NAND2_X1
X$13988 \$1358 \$1578 VSS VDD \$2785 NAND2_X1
X$13989 \$2670 VSS VDD \$2674 INV_X1
X$13990 \$2785 VSS VDD \$2778 INV_X1
X$13991 \$2778 \$2784 \$2152 VDD VSS \$2420 HA_X1
X$14002 \$2768 VSS VDD \$2817 INV_X1
X$14005 \$1855 \$1467 VSS VDD \$2913 NAND2_X1
X$14008 \$2915 VSS VDD \$2914 INV_X1
X$14010 \$1959 \$1357 VSS VDD \$2915 NAND2_X1
X$14014 \$1959 \$1580 VSS VDD \$2793 NAND2_X1
X$14015 VSS \$2918 \$2668 \$2416 \$2793 \$3016 VDD FA_X1
X$14019 \$2921 \$1475 VSS VDD \$2773 NAND2_X1
X$14020 \$2773 VSS VDD \$2784 INV_X1
X$14025 VSS \$3020 \$I72351 \$1586 \$2774 \$2922 VDD DFFR_X1
X$14043 \$747 \$477 VDD VSS \$775 XNOR2_X1
X$14044 \$748 \$746 \$1226 VSS \$747 VDD AOI21_X1
X$14048 dxin[1] VSS VDD \$1025 BUF_X1
X$14059 \$779 \$749 \$746 VDD VSS \$748 HA_X1
X$14060 \$852 VSS VDD \$779 INV_X1
X$14064 VSS \$855 \$852 \$929 \$537 \$751 VDD FA_X1
X$14067 VSS \$796 \$855 \$789 \$786 \$821 VDD FA_X1
X$14068 \$859 VSS VDD \$821 INV_X1
X$14073 \$929 VSS VDD \$961 INV_X1
X$14078 \$360 VSS VDD \$1140 INV_X1
X$14081 \$866 \$864 \$360 VDD VSS \$362 HA_X1
X$14087 \$484 \$215 VSS VDD \$864 NOR2_X1
X$14088 \$484 \$213 VSS VDD \$866 NOR2_X1
X$14092 \$1093 \$19 VSS VDD \$752 NAND2_X1
X$14097 VSS \$881 \$796 \$823 \$879 \$809 VDD FA_X1
X$14101 \$1062 \$32 VSS VDD \$889 NAND2_X1
X$14105 \$1009 VSS VDD \$32 INV_X1
X$14106 VSS \$889 \$881 \$982 \$825 \$932 VDD FA_X1
X$14107 \$628 \$66 VSS VDD \$932 NAND2_X1
X$14108 \$1098 VSS VDD \$66 INV_X1
X$14112 \$828 \$376 VSS VDD \$807 NAND2_X1
X$14113 \$816 VSS VDD \$828 INV_X1
X$14117 VSS \$377 \$816 \$168 \$910 \$43 VDD DFFR_X1
X$14126 VSS \$1012 \$I72820 \$910 \$908 \$43 VDD DFFR_X1
X$14131 \$1014 \$999 VDD VSS \$635 XNOR2_X1
X$14135 \$988 VSS VDD \$999 INV_X1
X$14138 \$934 VSS VDD \$997 INV_X1
X$14139 \$934 \$935 VSS VDD \$733 NAND2_X1
X$14140 \$1102 \$997 VSS VDD \$637 NAND2_X1
X$14141 VSS \$923 \$636 \$994 \$935 \$992 VDD FA_X1
X$14142 \$817 \$643 VSS VDD \$924 NAND2_X1
X$14143 VSS \$34 \$I72911 \$908 \$817 \$43 VDD DFFR_X1
X$14145 \$817 \$467 VSS VDD \$987 NAND2_X1
X$14146 \$831 \$643 VSS VDD \$833 NAND2_X1
X$14150 \$831 \$817 VSS VDD \$814 XOR2_X1
X$14154 VSS \$989 \$992 \$991 \$936 \$924 VDD FA_X1
X$14156 \$831 \$938 VSS VDD \$989 NAND2_X1
X$14158 VSS \$986 \$988 \$923 \$987 \$833 VDD FA_X1
X$14160 \$608 \$985 VSS VDD \$986 NAND2_X1
X$14162 \$985 VSS VDD \$938 INV_X1
X$14166 \$298 \$938 \$835 VDD VSS \$984 HA_X1
X$14169 \$984 VSS VDD \$940 INV_X1
X$14170 \$644 \$835 VSS VDD \$760 NAND2_X1
X$14172 \$644 VSS VDD \$646 INV_X1
X$14179 \$835 VSS VDD \$983 INV_X1
X$14181 \$983 \$1066 \$940 VDD \$645 VSS OAI21_X1
X$14182 \$940 \$646 \$802 \$760 \$977 VDD VSS \$973 OAI221_X1
X$14183 \$941 VSS VDD \$1021 INV_X1
X$14184 \$942 VSS VDD \$977 INV_X1
X$14187 \$1021 \$943 \$760 VSS VDD \$944 NOR3_X1
X$14190 \$973 \$944 \$1050 VSS \$970 VDD AOI21_X1
X$14191 \$972 \$945 \$970 VDD \$149 VSS OAI21_X1
X$14192 \$1343 \$944 VSS VDD \$972 NAND2_X1
X$14199 VSS \$1023 \$I72464 \$947 \$968 \$175 VDD DFFR_X1
X$14202 \$791 \$904 VSS VDD \$1172 NAND2_X1
X$14205 \$899 \$792 \$648 VDD VSS \$901 HA_X1
X$14206 \$901 VSS VDD \$791 INV_X1
X$14210 VSS \$1023 \$I72926 \$899 \$783 \$175 VDD DFFR_X1
X$14213 \$898 \$763 VDD VSS \$783 XNOR2_X1
X$14216 \$887 \$778 \$766 VSS \$898 VDD AOI21_X1
X$14217 \$764 \$765 \$839 VDD \$894 VSS OAI21_X1
X$14218 \$655 VSS VDD \$765 INV_X1
X$14219 \$656 \$765 \$839 VDD \$887 VSS OAI21_X1
X$14223 \$898 VSS VDD \$1024 INV_X1
X$14225 \$763 \$894 VSS VDD \$948 NAND2_X1
X$14227 \$766 VSS VDD \$773 INV_X1
X$14229 \$841 \$770 \$653 VDD VSS \$766 HA_X1
X$14230 \$870 VSS VDD \$839 INV_X1
X$14231 \$867 \$767 \$655 VDD VSS \$870 HA_X1
X$14235 VSS \$771 \$867 \$657 \$1118 \$860 VDD FA_X1
X$14239 VSS \$846 \$514 \$851 \$840 \$958 VDD FA_X1
X$14240 \$857 VSS VDD \$860 INV_X1
X$14242 \$851 VSS VDD \$770 INV_X1
X$14244 \$850 VSS VDD \$840 INV_X1
X$14245 \$1041 \$768 \$850 VDD VSS \$771 HA_X1
X$14246 \$843 VSS VDD \$768 INV_X1
X$14256 VSS \$1039 \$857 \$843 \$957 \$955 VDD FA_X1
X$14259 \$956 VSS VDD \$957 INV_X1
X$14261 \$1033 VSS VDD \$846 INV_X1
X$14264 \$949 \$1121 \$953 VDD VSS \$1027 HA_X1
X$14265 \$1026 \$950 VSS VDD \$841 NAND2_X1
X$14266 \$953 \$1362 VSS VDD \$950 NAND2_X1
X$14287 \$255 VSS VDD \$531 INV_X1
X$14290 \$416 VSS VDD \$254 INV_X1
X$14291 VSS \$362 \$416 \$420 \$360 \$418 VDD FA_X1
X$14292 VSS \$362 \$71 \$107 \$360 \$330 VDD FA_X1
X$14294 \$364 VSS VDD \$330 INV_X1
X$14295 VSS \$365 \$364 \$87 \$482 \$335 VDD FA_X1
X$14296 \$430 VSS VDD \$365 INV_X1
X$14299 \$435 VSS VDD \$288 INV_X1
X$14302 \$441 \$19 VSS VDD \$341 NAND2_X1
X$14303 \$308 VSS VDD \$441 INV_X1
X$14304 \$569 \$19 VSS VDD \$567 NAND2_X1
X$14305 \$308 \$32 VSS VDD \$371 NAND2_X1
X$14317 \$227 \$209 VDD VSS \$406 XNOR2_X1
X$14319 \$479 \$477 \$359 VSS \$252 VDD AOI21_X1
X$14320 \$414 \$531 \$477 VDD VSS \$479 HA_X1
X$14322 \$524 VSS VDD \$414 INV_X1
X$14324 VSS \$480 \$524 \$535 \$331 \$481 VDD FA_X1
X$14326 \$539 VSS VDD \$481 INV_X1
X$14327 \$543 VSS VDD \$546 INV_X1
X$14328 VSS \$362 \$539 \$543 \$360 \$541 VDD FA_X1
X$14331 \$420 VSS VDD \$329 INV_X1
X$14334 \$536 VSS VDD \$541 INV_X1
X$14335 VSS \$426 \$536 \$483 \$486 \$482 VDD FA_X1
X$14336 VSS \$432 \$418 \$435 \$366 \$430 VDD FA_X1
X$14337 \$193 \$487 VSS VDD \$432 NOR2_X1
X$14338 \$441 \$213 VSS VDD \$565 NOR2_X1
X$14342 VSS \$371 \$370 \$572 \$567 \$575 VDD FA_X1
X$14343 \$257 \$66 VSS VDD \$575 NAND2_X1
X$14345 \$168 \$111 VSS VDD \$486 NAND2_X1
X$14347 \$487 VSS VDD \$111 INV_X1
X$14350 \$257 \$111 VSS VDD \$375 NAND2_X1
X$14351 \$590 \$376 VSS VDD \$426 NAND2_X1
X$14352 \$308 \$111 VSS VDD \$632 NAND2_X1
X$14356 \$592 VSS VDD \$590 INV_X1
X$14357 \$377 VSS VDD \$I55303 INV_X1
X$14358 VSS \$214 \$592 \$134 \$588 \$43 VDD DFFR_X1
X$14359 VSS \$377 \$I72602 \$1842 \$257 \$43 VDD DFFR_X1
X$14366 VSS \$214 \$I72510 \$588 \$380 \$43 VDD DFFR_X1
X$14368 \$378 \$494 VSS VDD \$495 NAND2_X1
X$14369 \$499 \$496 VSS VDD \$494 NAND2_X1
X$14370 \$497 VSS VDD \$607 INV_X1
X$14371 \$607 \$381 VSS VDD \$496 NAND2_X1
X$14373 VSS \$34 \$I72407 \$619 \$612 \$43 VDD DFFR_X1
X$14374 VSS \$34 \$I72447 \$610 \$608 \$43 VDD DFFR_X1
X$14375 \$34 VSS VDD \$I56076 INV_X1
X$14377 \$463 VSS VDD \$34 CLKBUF_X3
X$14381 VSS \$263 \$353 \$298 \$395 \$43 VDD DFFR_X1
X$14384 \$464 \$353 VSS VDD \$349 XOR2_X1
X$14385 \$386 \$394 \$347 VSS \$351 VDD AOI21_X1
X$14387 \$463 VSS VDD \$263 CLKBUF_X3
X$14388 \$263 VSS VDD CLKBUF_X1
X$14390 \$265 \$345 \$390 VDD VSS \$343 HA_X1
X$14391 \$217 \$310 \$218 \$287 VSS VDD \$345 NAND4_X1
X$14392 \$217 \$287 VSS VDD \$384 NOR2_X2
X$14396 \$384 VSS VDD \$741 INV_X1
X$14397 \$384 \$386 VSS VDD \$505 NOR2_X1
X$14398 \$505 VSS VDD \$467 BUF_X1
X$14400 \$385 VSS VDD \$386 INV_X1
X$14402 \$343 \$386 VSS VDD \$464 NOR2_X1
X$14407 \$390 VSS VDD \$394 INV_X1
X$14408 \$390 \$310 VSS VDD \$584 NOR2_X1
X$14411 \$310 \$218 VSS VDD \$506 NOR2_X1
X$14412 \$506 \$384 VSS VDD \$443 NAND2_X1
X$14414 \$265 \$443 VSS VDD \$439 NAND2_X1
X$14416 \$396 \$439 VSS VDD \$576 NAND2_X1
X$14419 \$222 \$270 VSS VDD \$399 NOR2_X1
X$14420 \$222 \$394 \$385 VSS VDD \$269 NAND3_X1
X$14421 \$385 \$270 \$394 VDD VSS \$317 AND3_X1
X$14423 \$405 \$317 \$325 VDD VSS \$271 HA_X1
X$14425 \$269 VSS VDD \$323 INV_X1
X$14427 \$530 \$319 \$271 VSS VDD \$529 NAND3_X1
X$14428 \$322 \$323 \$319 VDD VSS \$517 HA_X1
X$14430 VSS \$221 \$273 \$322 \$403 \$175 VDD DFFR_X1
X$14444 \$265 VSS VDD \$566 INV_X1
X$14445 \$566 \$506 \$384 VSS VDD \$396 NAND3_X1
X$14447 \$576 \$507 VSS \$385 VDD NAND2_X4
X$14449 \$434 \$220 VSS VDD \$724 NOR2_X2
X$14451 VSS \$221 \$I72450 \$508 \$534 \$175 VDD DFFR_X1
X$14452 \$398 \$399 VSS VDD \$434 NAND2_X1
X$14458 \$221 VSS VDD \$I55540 INV_X1
X$14459 \$553 VSS VDD \$221 CLKBUF_X3
X$14460 \$401 \$530 VDD VSS \$534 XNOR2_X1
X$14461 \$407 \$522 \$529 VSS VDD \$511 NAND3_X1
X$14462 \$517 \$530 VSS VDD \$407 NAND2_X1
X$14590 \$105 \$115 \$178 VDD VSS \$140 HA_X1
X$14591 \$117 VSS VDD \$105 INV_X1
X$14601 \$178 VSS VDD \$164 INV_X1
X$14603 \$164 \$165 \$166 VDD \$183 VSS OAI21_X1
X$14604 \$140 VSS VDD \$166 INV_X1
X$14607 \$183 \$188 VSS VDD \$750 XOR2_X1
X$14608 VSS \$120 \$117 \$154 \$97 \$121 VDD FA_X1
X$14613 \$154 VSS VDD \$179 INV_X1
X$14616 \$71 VSS VDD \$121 INV_X1
X$14618 VSS \$141 \$120 \$158 \$132 \$80 VDD FA_X1
X$14621 \$107 VSS VDD \$80 INV_X1
X$14623 VSS \$191 \$141 \$239 \$156 \$87 VDD FA_X1
X$14625 VSS \$129 \$81 \$132 \$87 \$138 VDD FA_X1
X$14628 \$110 VSS VDD \$83 INV_X1
X$14629 \$109 \$19 VSS VDD \$135 NAND2_X1
X$14633 \$193 \$19 VSS VDD \$65 NAND2_X1
X$14635 VSS \$153 \$138 \$156 \$142 \$131 VDD FA_X1
X$14637 VSS \$67 \$I72697 \$143 \$66 \$43 VDD DFFR_X1
X$14638 VSS \$67 \$I72947 \$112 \$111 \$43 VDD DFFR_X1
X$14643 \$134 VSS VDD \$193 INV_X1
X$14646 \$211 \$19 VSS VDD \$142 NAND2_X1
X$14648 \$168 \$32 VSS VDD \$153 NAND2_X1
X$14651 VSS \$377 \$I72481 \$169 \$143 \$43 VDD DFFR_X1
X$14652 VSS \$214 \$I72480 \$171 \$112 \$43 VDD DFFR_X1
X$14660 \$144 VSS VDD \$148 INV_X1
X$14683 \$216 \$144 VSS VDD \$145 NAND2_X1
X$14684 \$145 \$196 \$146 VSS VDD \$302 NAND3_X1
X$14685 \$144 \$296 \$149 VSS VDD \$146 NAND3_X1
X$14686 \$150 \$148 VDD VSS \$180 XNOR2_X1
X$14687 \$149 \$172 VDD VSS \$173 XNOR2_X1
X$14691 VSS \$263 \$I72518 \$218 \$180 \$43 VDD DFFR_X1
X$14737 \$48 \$41 VDD VSS \$60 XNOR2_X1
X$14738 \$87 \$92 VDD VSS \$41 XNOR2_X1
X$14740 \$61 \$71 VDD VSS \$48 XNOR2_X1
X$14754 \$60 \$89 VDD VSS \$188 XNOR2_X1
X$14755 VSS \$73 \$92 \$115 \$71 \$79 VDD FA_X1
X$14756 \$96 VSS VDD \$79 INV_X1
X$14757 VSS \$102 \$96 \$97 \$80 \$81 VDD FA_X1
X$14759 \$42 VSS VDD \$73 INV_X1
X$14761 \$107 \$62 VDD VSS \$82 XNOR2_X1
X$14762 VSS \$101 \$62 \$56 \$63 \$77 VDD FA_X1
X$14764 \$76 VSS VDD \$77 INV_X1
X$14765 \$31 VSS VDD \$102 INV_X1
X$14767 \$82 \$101 VDD VSS \$89 XNOR2_X1
X$14768 \$87 VSS VDD \$63 INV_X1
X$14772 \$64 VSS VDD \$30 INV_X1
X$14774 VSS \$65 \$76 \$58 \$83 \$74 VDD FA_X1
X$14779 VSS \$98 \$64 \$129 \$135 \$83 VDD FA_X1
X$14782 \$134 \$32 VSS VDD \$98 NAND2_X1
X$14785 \$134 \$66 VSS VDD \$131 NAND2_X1
X$14787 \$804 VSS VDD \$74 INV_X1
X$14792 \$67 VSS VDD \$I74120 INV_X2
X$14793 \$85 VSS VDD \$67 CLKBUF_X3
X$14794 VSS \$67 \$I72700 \$44 \$68 \$43 VDD DFFR_X1
X$14878 \$251 \$164 VDD VSS \$275 XNOR2_X1
X$14879 \$163 VSS VDD \$209 INV_X1
X$14880 \$226 \$163 \$227 VSS \$165 VDD AOI21_X1
X$14881 \$232 \$179 \$163 VDD VSS \$226 HA_X1
X$14884 \$209 \$252 \$253 VDD \$251 VSS OAI21_X1
X$14885 \$226 VSS VDD \$253 INV_X1
X$14888 \$233 VSS VDD \$232 INV_X1
X$14893 \$168 VSS VDD \$109 INV_X1
X$14896 VSS \$280 \$233 \$255 \$158 \$254 VDD FA_X1
X$14899 VSS \$284 \$280 \$331 \$239 \$329 VDD FA_X1
X$14903 VSS \$370 \$284 \$291 \$246 \$288 VDD FA_X1
X$14904 VSS \$210 \$191 \$246 \$341 \$247 VDD FA_X1
X$14906 \$168 \$66 VSS VDD \$247 NAND2_X1
X$14911 \$213 VSS VDD \$204 INV_X1
X$14912 VSS \$214 \$I72766 \$244 \$204 \$43 VDD DFFR_X1
X$14913 VSS \$214 \$I72638 \$304 \$244 \$43 VDD DFFR_X1
X$14918 \$298 \$351 \$144 VDD VSS \$238 HA_X1
X$14919 \$238 VSS VDD \$196 INV_X1
X$14920 \$296 VSS VDD \$172 INV_X1
X$14921 \$216 VSS VDD \$236 INV_X1
X$14922 \$172 \$389 \$236 VDD \$150 VSS OAI21_X1
X$14923 VSS \$263 \$I72731 \$217 \$173 \$43 VDD DFFR_X1
X$14928 VSS \$221 \$I72778 \$222 \$224 \$175 VDD DFFR_X1
X$14932 \$257 \$32 VSS VDD \$210 NAND2_X1
X$14933 \$257 VSS VDD \$211 INV_X1
X$14939 \$85 VSS VDD \$214 CLKBUF_X3
X$14943 VSS \$214 \$I72559 \$303 \$304 \$43 VDD DFFR_X1
X$14949 \$298 \$467 \$296 VDD VSS \$216 HA_X1
X$14951 \$302 \$349 VDD VSS \$293 XNOR2_X1
X$14955 \$218 VSS VDD \$347 INV_X1
X$14956 VSS \$263 \$265 \$287 \$293 \$43 VDD DFFR_X1
X$14958 \$218 \$287 VSS VDD \$281 NOR2_X1
X$14960 \$310 VSS VDD \$267 INV_X1
X$14961 \$217 \$267 VSS VDD \$268 NOR2_X1
X$14962 \$281 \$268 VSS VDD \$220 NAND2_X1
X$14965 VSS \$221 \$I72424 \$270 \$325 \$175 VDD DFFR_X1
X$14969 \$271 VSS VDD \$276 INV_X1
X$14970 VSS \$276 \$401 \$223 \$269 \$273 VDD FA_X1
X$14972 \$223 VSS VDD \$224 INV_X1
X$15016 \$9136 VSS VDD \$8639 INV_X2
X$15026 \$9128 VSS VDD \$9325 INV_X1
X$15031 \$9314 \$9435 VDD VSS \$9526 XNOR2_X1
X$15032 \$9436 \$9529 \$9437 \$8996 \$9325 VDD VSS \$9007 OAI221_X1
X$15034 VSS \$9439 \$I72395 \$9130 \$9526 \$5920 VDD DFFR_X1
X$15035 \$9130 \$6298 VSS VDD \$9136 NAND2_X1
X$15039 \$9315 \$9442 VDD VSS \$9320 XNOR2_X1
X$15042 VSS \$9439 \$I72328 \$9447 \$9320 \$5920 VDD DFFR_X1
X$15045 VSS \$9446 \$9458 \$9317 \$9447 \$9316 VDD NOR4_X4
X$15060 VSS \$11803 \$I72871 \$12559 \$12527 \$10454 VDD DFFR_X1
X$15061 VSS \$12532 \$12775 \$12488 \$12533 \$12348 VDD FA_X1
X$15072 \$12589 VSS VDD \$12533 INV_X1
X$15075 \$12488 VSS VDD \$12826 INV_X1
X$15078 VSS \$12319 \$12729 \$12778 \$12264 \$12589 VDD FA_X1
X$15080 VSS \$12268 \$12590 \$12543 \$12429 \$12593 VDD FA_X1
X$15081 \$12351 VSS VDD \$12490 INV_X1
X$15083 VSS \$12542 \$12489 \$13002 \$12541 \$12543 VDD FA_X1
X$15087 VSS \$12549 \$12781 \$12494 \$12357 \$12548 VDD FA_X1
X$15089 VSS \$12495 \$12493 \$12496 \$12492 \$12553 VDD FA_X1
X$15093 \$12638 VSS VDD \$12743 INV_X1
X$15096 \$12644 VSS VDD \$12687 INV_X1
X$15101 \$12358 VSS VDD \$12549 INV_X1
X$15104 \$12491 VSS VDD \$12648 INV_X1
X$15105 VSS \$12648 \$12649 \$12650 \$12647 \$11832 VDD FA_X1
X$15106 VSS \$12653 \$12688 \$12497 \$12496 \$12650 VDD FA_X1
X$15107 VSS \$12558 \$12689 \$12271 \$12497 \$12362 VDD FA_X1
X$15108 \$11376 VSS VDD \$11583 CLKBUF_X3
X$15114 \$12559 \$12595 \$12499 VDD VSS \$12596 HA_X1
X$15116 \$12596 \$12499 \$12368 VSS \$12562 VDD AOI21_X1
X$15118 \$12568 \$12596 VSS VDD \$12692 OR2_X1
X$15120 \$12499 VSS VDD \$12597 INV_X1
X$15121 \$12597 \$12367 \$12253 VSS \$12568 VDD AOI21_X1
X$15128 \$12368 \$12597 VDD VSS \$12502 XNOR2_X1
X$15132 \$12599 VSS VDD \$12372 INV_X1
X$15139 \$12601 \$12599 \$12183 VSS \$12600 VDD AOI21_X1
X$15142 \$10360 VSS VDD \$11529 BUF_X2
X$15144 \$11376 VSS VDD \$12184 CLKBUF_X3
X$15145 \$12184 VSS VDD \$I56583 INV_X1
X$15146 VSS \$12184 \$I72866 \$12584 \$12504 \$11529 VDD DFFR_X1
X$15150 \$12580 VSS VDD \$12585 INV_X1
X$15152 VSS \$12184 \$12607 \$9966 \$12584 \$11529 VDD DFFR_X1
X$15153 \$12573 VSS VDD \$12507 INV_X1
X$15154 \$12572 VSS VDD \$12508 INV_X1
X$15155 VSS \$12606 \$12573 \$12481 \$12560 \$12567 VDD FA_X1
X$15160 VSS \$12508 \$12860 \$12580 \$12863 \$12507 VDD FA_X1
X$15161 \$12605 \$12677 \$12281 VDD VSS \$12567 HA_X1
X$15162 \$9966 \$12611 VSS VDD \$12510 NAND2_X1
X$15164 \$12675 VSS VDD \$12677 INV_X1
X$15165 \$10615 \$12290 VSS VDD \$12675 NAND2_X1
X$15167 \$12512 VSS VDD \$12564 INV_X1
X$15169 \$11383 \$11417 VSS VDD \$12512 NAND2_X1
X$15173 \$12607 \$10960 VSS VDD \$12665 NOR2_X1
X$15178 \$12008 \$12516 VDD VSS \$12547 XNOR2_X1
X$15181 \$12613 \$12516 VSS VDD \$12014 NAND2_X1
X$15183 \$12518 \$12614 \$12635 \$12014 \$12536 VDD VSS \$12195 OAI221_X1
X$15188 \$12393 \$12520 VDD VSS \$12524 XNOR2_X1
X$15190 \$12525 VSS VDD \$12521 INV_X4
X$15207 VSS \$12664 \$12673 \$12765 \$12665 \$12759 VDD FA_X1
X$15208 \$12663 VSS VDD \$12664 INV_X1
X$15210 \$10117 \$11191 VSS VDD \$12663 NAND2_X1
X$15214 \$12611 VSS VDD \$12604 INV_X1
X$15215 \$12516 VSS VDD \$12646 INV_X1
X$15216 \$12646 \$12317 \$12518 VDD \$12612 VSS OAI21_X1
X$15217 \$12615 \$12290 \$12516 VDD VSS \$12637 HA_X1
X$15218 \$12637 VSS VDD \$12518 INV_X1
X$15220 VSS \$12391 \$12628 \$12615 \$10471 \$11529 VDD DFFR_X1
X$15223 \$12626 \$12628 VSS VDD \$12627 XOR2_X1
X$15228 \$12620 \$12521 VSS VDD \$12626 NOR2_X1
X$15229 \$12716 \$12521 \$11450 VSS VDD NOR2_X4
.ENDS tf_lms_sv

.SUBCKT NAND3_X4 A2 A1 A3 VSS ZN VDD
M$1 ZN A3 VDD VDD PMOS_VTL L=0.05U W=2.52U AS=0.19845P AD=0.19845P PS=3.78U
+ PD=3.78U
M$2 VDD A2 ZN VDD PMOS_VTL L=0.05U W=2.52U AS=0.1764P AD=0.1764P PS=3.08U
+ PD=3.08U
M$3 ZN A1 VDD VDD PMOS_VTL L=0.05U W=2.52U AS=0.1764P AD=0.1764P PS=3.08U
+ PD=3.08U
M$13 \$15 A3 VSS VSS NMOS_VTL L=0.05U W=0.415U AS=0.043575P AD=0.02905P
+ PS=1.04U PD=0.555U
M$14 \$14 A2 \$15 VSS NMOS_VTL L=0.05U W=0.415U AS=0.02905P AD=0.02905P
+ PS=0.555U PD=0.555U
M$15 ZN A1 \$14 VSS NMOS_VTL L=0.05U W=0.415U AS=0.02905P AD=0.02905P PS=0.555U
+ PD=0.555U
M$16 \$12 A1 ZN VSS NMOS_VTL L=0.05U W=0.415U AS=0.02905P AD=0.02905P PS=0.555U
+ PD=0.555U
M$17 \$10 A2 \$12 VSS NMOS_VTL L=0.05U W=0.415U AS=0.02905P AD=0.02905P
+ PS=0.555U PD=0.555U
M$18 VSS A3 \$10 VSS NMOS_VTL L=0.05U W=0.415U AS=0.02905P AD=0.02905P
+ PS=0.555U PD=0.555U
M$19 \$11 A3 VSS VSS NMOS_VTL L=0.05U W=0.415U AS=0.02905P AD=0.02905P
+ PS=0.555U PD=0.555U
M$20 \$9 A2 \$11 VSS NMOS_VTL L=0.05U W=0.415U AS=0.02905P AD=0.02905P
+ PS=0.555U PD=0.555U
M$21 ZN A1 \$9 VSS NMOS_VTL L=0.05U W=0.415U AS=0.02905P AD=0.02905P PS=0.555U
+ PD=0.555U
M$22 \$16 A1 ZN VSS NMOS_VTL L=0.05U W=0.415U AS=0.02905P AD=0.02905P PS=0.555U
+ PD=0.555U
M$23 \$13 A2 \$16 VSS NMOS_VTL L=0.05U W=0.415U AS=0.02905P AD=0.02905P
+ PS=0.555U PD=0.555U
M$24 VSS A3 \$13 VSS NMOS_VTL L=0.05U W=0.415U AS=0.02905P AD=0.043575P
+ PS=0.555U PD=1.04U
.ENDS NAND3_X4

.SUBCKT BUF_X4 A VDD Z VSS
M$1 \$2 A VDD VDD PMOS_VTL L=0.05U W=1.26U AS=0.11025P AD=0.0882P PS=2.24U
+ PD=1.54U
M$3 Z \$2 VDD VDD PMOS_VTL L=0.05U W=2.52U AS=0.1764P AD=0.19845P PS=3.08U
+ PD=3.78U
M$7 \$2 A VSS VSS NMOS_VTL L=0.05U W=0.83U AS=0.072625P AD=0.0581P PS=1.595U
+ PD=1.11U
M$9 Z \$2 VSS VSS NMOS_VTL L=0.05U W=1.66U AS=0.1162P AD=0.130725P PS=2.22U
+ PD=2.705U
.ENDS BUF_X4

.SUBCKT AOI21_X4 VSS ZN A B2 B1 VDD
M$1 VDD A \$11 VDD PMOS_VTL L=0.05U W=2.52U AS=0.19845P AD=0.1764P PS=3.78U
+ PD=3.08U
M$5 ZN B2 \$11 VDD PMOS_VTL L=0.05U W=2.52U AS=0.1764P AD=0.19845P PS=3.08U
+ PD=3.78U
M$6 \$11 B1 ZN VDD PMOS_VTL L=0.05U W=2.52U AS=0.1764P AD=0.1764P PS=3.08U
+ PD=3.08U
M$13 ZN A VSS VSS NMOS_VTL L=0.05U W=1.66U AS=0.130725P AD=0.1162P PS=2.705U
+ PD=2.22U
M$17 \$8 B2 VSS VSS NMOS_VTL L=0.05U W=0.415U AS=0.02905P AD=0.02905P PS=0.555U
+ PD=0.555U
M$18 ZN B1 \$8 VSS NMOS_VTL L=0.05U W=0.415U AS=0.02905P AD=0.02905P PS=0.555U
+ PD=0.555U
M$19 \$9 B1 ZN VSS NMOS_VTL L=0.05U W=0.415U AS=0.02905P AD=0.02905P PS=0.555U
+ PD=0.555U
M$20 VSS B2 \$9 VSS NMOS_VTL L=0.05U W=0.415U AS=0.02905P AD=0.02905P PS=0.555U
+ PD=0.555U
M$21 \$6 B2 VSS VSS NMOS_VTL L=0.05U W=0.415U AS=0.02905P AD=0.02905P PS=0.555U
+ PD=0.555U
M$22 ZN B1 \$6 VSS NMOS_VTL L=0.05U W=0.415U AS=0.02905P AD=0.02905P PS=0.555U
+ PD=0.555U
M$23 \$7 B1 ZN VSS NMOS_VTL L=0.05U W=0.415U AS=0.02905P AD=0.02905P PS=0.555U
+ PD=0.555U
M$24 VSS B2 \$7 VSS NMOS_VTL L=0.05U W=0.415U AS=0.02905P AD=0.043575P
+ PS=0.555U PD=1.04U
.ENDS AOI21_X4

.SUBCKT AND4_X1 A1 A2 A3 A4 VDD VSS ZN
M$1 \$5 A1 VDD VDD PMOS_VTL L=0.05U W=0.315U AS=0.033075P AD=0.02205P PS=0.84U
+ PD=0.455U
M$2 VDD A2 \$5 VDD PMOS_VTL L=0.05U W=0.315U AS=0.02205P AD=0.02205P PS=0.455U
+ PD=0.455U
M$3 \$5 A3 VDD VDD PMOS_VTL L=0.05U W=0.315U AS=0.02205P AD=0.02205P PS=0.455U
+ PD=0.455U
M$4 \$5 A4 VDD VDD PMOS_VTL L=0.05U W=0.315U AS=0.033075P AD=0.02205P PS=0.77U
+ PD=0.455U
M$5 ZN \$5 VDD VDD PMOS_VTL L=0.05U W=0.63U AS=0.033075P AD=0.06615P PS=0.77U
+ PD=1.47U
M$6 \$12 A1 \$5 VSS NMOS_VTL L=0.05U W=0.21U AS=0.02205P AD=0.0147P PS=0.63U
+ PD=0.35U
M$7 \$13 A2 \$12 VSS NMOS_VTL L=0.05U W=0.21U AS=0.0147P AD=0.0147P PS=0.35U
+ PD=0.35U
M$8 \$11 A3 \$13 VSS NMOS_VTL L=0.05U W=0.21U AS=0.0147P AD=0.0147P PS=0.35U
+ PD=0.35U
M$9 VSS A4 \$11 VSS NMOS_VTL L=0.05U W=0.21U AS=0.0147P AD=0.021875P PS=0.35U
+ PD=0.555U
M$10 ZN \$5 VSS VSS NMOS_VTL L=0.05U W=0.415U AS=0.021875P AD=0.043575P
+ PS=0.555U PD=1.04U
.ENDS AND4_X1

.SUBCKT AND3_X1 A1 A2 A3 VDD VSS ZN
M$1 VDD A1 \$4 VDD PMOS_VTL L=0.05U W=0.315U AS=0.033075P AD=0.02205P PS=0.84U
+ PD=0.455U
M$2 \$4 A2 VDD VDD PMOS_VTL L=0.05U W=0.315U AS=0.02205P AD=0.02205P PS=0.455U
+ PD=0.455U
M$3 \$4 A3 VDD VDD PMOS_VTL L=0.05U W=0.315U AS=0.033075P AD=0.02205P PS=0.77U
+ PD=0.455U
M$4 ZN \$4 VDD VDD PMOS_VTL L=0.05U W=0.63U AS=0.033075P AD=0.06615P PS=0.77U
+ PD=1.47U
M$5 \$10 A1 \$4 VSS NMOS_VTL L=0.05U W=0.21U AS=0.02205P AD=0.0147P PS=0.63U
+ PD=0.35U
M$6 \$11 A2 \$10 VSS NMOS_VTL L=0.05U W=0.21U AS=0.0147P AD=0.0147P PS=0.35U
+ PD=0.35U
M$7 VSS A3 \$11 VSS NMOS_VTL L=0.05U W=0.21U AS=0.0147P AD=0.021875P PS=0.35U
+ PD=0.555U
M$8 ZN \$4 VSS VSS NMOS_VTL L=0.05U W=0.415U AS=0.021875P AD=0.043575P
+ PS=0.555U PD=1.04U
.ENDS AND3_X1

.SUBCKT NOR4_X4 VSS A1 A2 A3 A4 ZN VDD
M$1 \$9 A3 \$10 VDD PMOS_VTL L=0.05U W=2.52U AS=0.19845P AD=0.1764P PS=3.78U
+ PD=3.08U
M$5 VDD A4 \$10 VDD PMOS_VTL L=0.05U W=2.52U AS=0.1764P AD=0.19845P PS=3.08U
+ PD=3.78U
M$9 ZN A1 \$8 VDD PMOS_VTL L=0.05U W=2.52U AS=0.19845P AD=0.1764P PS=3.78U
+ PD=3.08U
M$13 \$9 A2 \$8 VDD PMOS_VTL L=0.05U W=2.52U AS=0.1764P AD=0.19845P PS=3.08U
+ PD=3.78U
M$17 ZN A1 VSS VSS NMOS_VTL L=0.05U W=1.66U AS=0.130725P AD=0.1162P PS=2.705U
+ PD=2.22U
M$21 ZN A2 VSS VSS NMOS_VTL L=0.05U W=1.66U AS=0.1162P AD=0.130725P PS=2.22U
+ PD=2.705U
M$25 VSS A3 ZN VSS NMOS_VTL L=0.05U W=1.66U AS=0.130725P AD=0.1162P PS=2.705U
+ PD=2.22U
M$29 VSS A4 ZN VSS NMOS_VTL L=0.05U W=1.66U AS=0.1162P AD=0.130725P PS=2.22U
+ PD=2.705U
.ENDS NOR4_X4

.SUBCKT NOR3_X4 VSS A1 A2 A3 ZN VDD
M$1 ZN A1 \$8 VDD PMOS_VTL L=0.05U W=2.52U AS=0.19845P AD=0.1764P PS=3.78U
+ PD=3.08U
M$5 \$6 A2 \$8 VDD PMOS_VTL L=0.05U W=2.52U AS=0.1764P AD=0.19845P PS=3.08U
+ PD=3.78U
M$9 \$6 A3 VDD VDD PMOS_VTL L=0.05U W=2.52U AS=0.19845P AD=0.19845P PS=3.78U
+ PD=3.78U
M$13 ZN A3 VSS VSS NMOS_VTL L=0.05U W=1.66U AS=0.130725P AD=0.130725P PS=2.705U
+ PD=2.705U
M$17 ZN A1 VSS VSS NMOS_VTL L=0.05U W=1.66U AS=0.130725P AD=0.1162P PS=2.705U
+ PD=2.22U
M$21 ZN A2 VSS VSS NMOS_VTL L=0.05U W=1.66U AS=0.1162P AD=0.130725P PS=2.22U
+ PD=2.705U
.ENDS NOR3_X4

.SUBCKT OR2_X4 A2 A1 VSS ZN VDD
M$1 \$10 A2 VDD VDD PMOS_VTL L=0.05U W=0.63U AS=0.06615P AD=0.0441P PS=1.47U
+ PD=0.77U
M$2 \$4 A1 \$10 VDD PMOS_VTL L=0.05U W=0.63U AS=0.0441P AD=0.0441P PS=0.77U
+ PD=0.77U
M$3 \$9 A1 \$4 VDD PMOS_VTL L=0.05U W=0.63U AS=0.0441P AD=0.0441P PS=0.77U
+ PD=0.77U
M$4 VDD A2 \$9 VDD PMOS_VTL L=0.05U W=0.63U AS=0.0441P AD=0.0441P PS=0.77U
+ PD=0.77U
M$5 ZN \$4 VDD VDD PMOS_VTL L=0.05U W=2.52U AS=0.1764P AD=0.19845P PS=3.08U
+ PD=3.78U
M$9 \$4 A2 VSS VSS NMOS_VTL L=0.05U W=0.83U AS=0.072625P AD=0.0581P PS=1.595U
+ PD=1.11U
M$10 VSS A1 \$4 VSS NMOS_VTL L=0.05U W=0.83U AS=0.0581P AD=0.0581P PS=1.11U
+ PD=1.11U
M$13 ZN \$4 VSS VSS NMOS_VTL L=0.05U W=1.66U AS=0.1162P AD=0.130725P PS=2.22U
+ PD=2.705U
.ENDS OR2_X4

.SUBCKT XOR2_X2 B A VDD Z VSS
M$1 \$10 A \$3 VDD PMOS_VTL L=0.05U W=0.63U AS=0.06615P AD=0.0441P PS=1.47U
+ PD=0.77U
M$2 VDD B \$10 VDD PMOS_VTL L=0.05U W=0.63U AS=0.0441P AD=0.0441P PS=0.77U
+ PD=0.77U
M$3 \$6 \$3 VDD VDD PMOS_VTL L=0.05U W=1.26U AS=0.0882P AD=0.11025P PS=1.54U
+ PD=2.24U
M$4 Z A \$6 VDD PMOS_VTL L=0.05U W=1.26U AS=0.0882P AD=0.0882P PS=1.54U PD=1.54U
M$5 \$6 B Z VDD PMOS_VTL L=0.05U W=1.26U AS=0.0882P AD=0.0882P PS=1.54U PD=1.54U
M$9 \$3 A VSS VSS NMOS_VTL L=0.05U W=0.415U AS=0.043575P AD=0.02905P PS=1.04U
+ PD=0.555U
M$10 VSS B \$3 VSS NMOS_VTL L=0.05U W=0.415U AS=0.02905P AD=0.02905P PS=0.555U
+ PD=0.555U
M$11 Z \$3 VSS VSS NMOS_VTL L=0.05U W=0.83U AS=0.0581P AD=0.072625P PS=1.11U
+ PD=1.595U
M$12 \$12 A Z VSS NMOS_VTL L=0.05U W=0.415U AS=0.02905P AD=0.02905P PS=0.555U
+ PD=0.555U
M$13 VSS B \$12 VSS NMOS_VTL L=0.05U W=0.415U AS=0.02905P AD=0.02905P PS=0.555U
+ PD=0.555U
M$14 \$11 B VSS VSS NMOS_VTL L=0.05U W=0.415U AS=0.02905P AD=0.02905P PS=0.555U
+ PD=0.555U
M$15 Z A \$11 VSS NMOS_VTL L=0.05U W=0.415U AS=0.02905P AD=0.02905P PS=0.555U
+ PD=0.555U
.ENDS XOR2_X2

.SUBCKT AND2_X4 A2 A1 VDD ZN VSS
M$1 \$3 A2 VDD VDD PMOS_VTL L=0.05U W=1.26U AS=0.11025P AD=0.0882P PS=2.24U
+ PD=1.54U
M$2 VDD A1 \$3 VDD PMOS_VTL L=0.05U W=1.26U AS=0.0882P AD=0.0882P PS=1.54U
+ PD=1.54U
M$5 ZN \$3 VDD VDD PMOS_VTL L=0.05U W=2.52U AS=0.1764P AD=0.19845P PS=3.08U
+ PD=3.78U
M$9 \$10 A2 VSS VSS NMOS_VTL L=0.05U W=0.415U AS=0.043575P AD=0.02905P PS=1.04U
+ PD=0.555U
M$10 \$3 A1 \$10 VSS NMOS_VTL L=0.05U W=0.415U AS=0.02905P AD=0.02905P
+ PS=0.555U PD=0.555U
M$11 \$9 A1 \$3 VSS NMOS_VTL L=0.05U W=0.415U AS=0.02905P AD=0.02905P PS=0.555U
+ PD=0.555U
M$12 VSS A2 \$9 VSS NMOS_VTL L=0.05U W=0.415U AS=0.02905P AD=0.02905P PS=0.555U
+ PD=0.555U
M$13 ZN \$3 VSS VSS NMOS_VTL L=0.05U W=1.66U AS=0.1162P AD=0.130725P PS=2.22U
+ PD=2.705U
.ENDS AND2_X4

.SUBCKT NAND4_X4 VSS A3 A4 A1 A2 ZN VDD
M$1 VDD A1 ZN VDD PMOS_VTL L=0.05U W=2.52U AS=0.19845P AD=0.1764P PS=3.78U
+ PD=3.08U
M$5 VDD A2 ZN VDD PMOS_VTL L=0.05U W=2.52U AS=0.1764P AD=0.22365P PS=3.08U
+ PD=3.23U
M$9 VDD A3 ZN VDD PMOS_VTL L=0.05U W=2.52U AS=0.22365P AD=0.1764P PS=3.23U
+ PD=3.08U
M$13 VDD A4 ZN VDD PMOS_VTL L=0.05U W=2.52U AS=0.1764P AD=0.19845P PS=3.08U
+ PD=3.78U
M$17 \$5 A3 \$6 VSS NMOS_VTL L=0.05U W=1.66U AS=0.130725P AD=0.1162P PS=2.705U
+ PD=2.22U
M$21 VSS A4 \$6 VSS NMOS_VTL L=0.05U W=1.66U AS=0.1162P AD=0.130725P PS=2.22U
+ PD=2.705U
M$25 ZN A1 \$4 VSS NMOS_VTL L=0.05U W=1.66U AS=0.130725P AD=0.1162P PS=2.705U
+ PD=2.22U
M$29 \$5 A2 \$4 VSS NMOS_VTL L=0.05U W=1.66U AS=0.1162P AD=0.130725P PS=2.22U
+ PD=2.705U
.ENDS NAND4_X4

.SUBCKT NOR4_X2 A3 A2 A1 A4 VDD ZN VSS
M$1 \$14 A4 VDD VDD PMOS_VTL L=0.05U W=0.63U AS=0.06615P AD=0.0441P PS=1.47U
+ PD=0.77U
M$2 \$13 A3 \$14 VDD PMOS_VTL L=0.05U W=0.63U AS=0.0441P AD=0.0441P PS=0.77U
+ PD=0.77U
M$3 \$12 A2 \$13 VDD PMOS_VTL L=0.05U W=0.63U AS=0.0441P AD=0.0441P PS=0.77U
+ PD=0.77U
M$4 ZN A1 \$12 VDD PMOS_VTL L=0.05U W=0.63U AS=0.0441P AD=0.0441P PS=0.77U
+ PD=0.77U
M$5 \$11 A1 ZN VDD PMOS_VTL L=0.05U W=0.63U AS=0.0441P AD=0.0441P PS=0.77U
+ PD=0.77U
M$6 \$15 A2 \$11 VDD PMOS_VTL L=0.05U W=0.63U AS=0.0441P AD=0.0441P PS=0.77U
+ PD=0.77U
M$7 \$10 A3 \$15 VDD PMOS_VTL L=0.05U W=0.63U AS=0.0441P AD=0.0441P PS=0.77U
+ PD=0.77U
M$8 VDD A4 \$10 VDD PMOS_VTL L=0.05U W=0.63U AS=0.0441P AD=0.06615P PS=0.77U
+ PD=1.47U
M$9 ZN A4 VSS VSS NMOS_VTL L=0.05U W=0.83U AS=0.072625P AD=0.072625P PS=1.595U
+ PD=1.595U
M$10 VSS A3 ZN VSS NMOS_VTL L=0.05U W=0.83U AS=0.0581P AD=0.0581P PS=1.11U
+ PD=1.11U
M$11 ZN A2 VSS VSS NMOS_VTL L=0.05U W=0.83U AS=0.0581P AD=0.0581P PS=1.11U
+ PD=1.11U
M$12 VSS A1 ZN VSS NMOS_VTL L=0.05U W=0.83U AS=0.0581P AD=0.0581P PS=1.11U
+ PD=1.11U
.ENDS NOR4_X2

.SUBCKT NAND2_X2 A2 A1 VSS VDD ZN
M$1 ZN A2 VDD VDD PMOS_VTL L=0.05U W=1.26U AS=0.11025P AD=0.11025P PS=2.24U
+ PD=2.24U
M$2 VDD A1 ZN VDD PMOS_VTL L=0.05U W=1.26U AS=0.0882P AD=0.0882P PS=1.54U
+ PD=1.54U
M$5 \$9 A2 VSS VSS NMOS_VTL L=0.05U W=0.415U AS=0.043575P AD=0.02905P PS=1.04U
+ PD=0.555U
M$6 ZN A1 \$9 VSS NMOS_VTL L=0.05U W=0.415U AS=0.02905P AD=0.02905P PS=0.555U
+ PD=0.555U
M$7 \$8 A1 ZN VSS NMOS_VTL L=0.05U W=0.415U AS=0.02905P AD=0.02905P PS=0.555U
+ PD=0.555U
M$8 VSS A2 \$8 VSS NMOS_VTL L=0.05U W=0.415U AS=0.02905P AD=0.043575P PS=0.555U
+ PD=1.04U
.ENDS NAND2_X2

.SUBCKT OAI21_X4 A B2 B1 VDD VSS ZN
M$1 ZN A VDD VDD PMOS_VTL L=0.05U W=2.52U AS=0.19845P AD=0.1764P PS=3.78U
+ PD=3.08U
M$5 \$13 B2 VDD VDD PMOS_VTL L=0.05U W=0.63U AS=0.0441P AD=0.0441P PS=0.77U
+ PD=0.77U
M$6 ZN B1 \$13 VDD PMOS_VTL L=0.05U W=0.63U AS=0.0441P AD=0.0441P PS=0.77U
+ PD=0.77U
M$7 \$12 B1 ZN VDD PMOS_VTL L=0.05U W=0.63U AS=0.0441P AD=0.0441P PS=0.77U
+ PD=0.77U
M$8 VDD B2 \$12 VDD PMOS_VTL L=0.05U W=0.63U AS=0.0441P AD=0.0441P PS=0.77U
+ PD=0.77U
M$9 \$11 B2 VDD VDD PMOS_VTL L=0.05U W=0.63U AS=0.0441P AD=0.0441P PS=0.77U
+ PD=0.77U
M$10 ZN B1 \$11 VDD PMOS_VTL L=0.05U W=0.63U AS=0.0441P AD=0.0441P PS=0.77U
+ PD=0.77U
M$11 \$10 B1 ZN VDD PMOS_VTL L=0.05U W=0.63U AS=0.0441P AD=0.0441P PS=0.77U
+ PD=0.77U
M$12 VDD B2 \$10 VDD PMOS_VTL L=0.05U W=0.63U AS=0.0441P AD=0.06615P PS=0.77U
+ PD=1.47U
M$13 VSS A \$4 VSS NMOS_VTL L=0.05U W=1.66U AS=0.130725P AD=0.1162P PS=2.705U
+ PD=2.22U
M$17 ZN B2 \$4 VSS NMOS_VTL L=0.05U W=1.66U AS=0.1162P AD=0.130725P PS=2.22U
+ PD=2.705U
M$18 \$4 B1 ZN VSS NMOS_VTL L=0.05U W=1.66U AS=0.1162P AD=0.1162P PS=2.22U
+ PD=2.22U
.ENDS OAI21_X4

.SUBCKT INV_X8 A VSS VDD
M$1 ZN A VDD VDD PMOS_VTL L=0.05U W=5.04U AS=0.37485P AD=0.37485P PS=6.86U
+ PD=6.86U
M$9 ZN A VSS VSS NMOS_VTL L=0.05U W=3.32U AS=0.246925P AD=0.246925P PS=4.925U
+ PD=4.925U
.ENDS INV_X8

.SUBCKT BUF_X2 A VSS VDD Z
M$1 VDD A \$2 VDD PMOS_VTL L=0.05U W=0.63U AS=0.06615P AD=0.0441P PS=1.47U
+ PD=0.77U
M$2 Z \$2 VDD VDD PMOS_VTL L=0.05U W=1.26U AS=0.0882P AD=0.11025P PS=1.54U
+ PD=2.24U
M$4 VSS A \$2 VSS NMOS_VTL L=0.05U W=0.415U AS=0.043575P AD=0.02905P PS=1.04U
+ PD=0.555U
M$5 Z \$2 VSS VSS NMOS_VTL L=0.05U W=0.83U AS=0.0581P AD=0.072625P PS=1.11U
+ PD=1.595U
.ENDS BUF_X2

.SUBCKT XNOR2_X2 A B VSS VDD ZN
M$1 ZN A \$8 VDD PMOS_VTL L=0.05U W=0.63U AS=0.06615P AD=0.0441P PS=1.47U
+ PD=0.77U
M$2 \$11 A ZN VDD PMOS_VTL L=0.05U W=0.63U AS=0.0441P AD=0.0441P PS=0.77U
+ PD=0.77U
M$3 VDD B \$11 VDD PMOS_VTL L=0.05U W=0.63U AS=0.0441P AD=0.0441P PS=0.77U
+ PD=0.77U
M$4 \$8 B VDD VDD PMOS_VTL L=0.05U W=0.63U AS=0.0441P AD=0.06615P PS=0.77U
+ PD=1.47U
M$5 ZN \$1 VDD VDD PMOS_VTL L=0.05U W=1.26U AS=0.11025P AD=0.0882P PS=2.24U
+ PD=1.54U
M$7 \$1 B VDD VDD PMOS_VTL L=0.05U W=0.63U AS=0.0441P AD=0.0441P PS=0.77U
+ PD=0.77U
M$8 VDD A \$1 VDD PMOS_VTL L=0.05U W=0.63U AS=0.0441P AD=0.06615P PS=0.77U
+ PD=1.47U
M$9 \$6 A ZN VSS NMOS_VTL L=0.05U W=0.83U AS=0.072625P AD=0.0581P PS=1.595U
+ PD=1.11U
M$11 \$6 B ZN VSS NMOS_VTL L=0.05U W=0.83U AS=0.0581P AD=0.072625P PS=1.11U
+ PD=1.595U
M$13 \$6 \$1 VSS VSS NMOS_VTL L=0.05U W=0.83U AS=0.072625P AD=0.0581P PS=1.595U
+ PD=1.11U
M$15 \$12 B VSS VSS NMOS_VTL L=0.05U W=0.415U AS=0.02905P AD=0.02905P PS=0.555U
+ PD=0.555U
M$16 \$1 A \$12 VSS NMOS_VTL L=0.05U W=0.415U AS=0.02905P AD=0.043575P
+ PS=0.555U PD=1.04U
.ENDS XNOR2_X2

.SUBCKT NAND2_X4 A2 A1 VSS ZN VDD
M$1 ZN A2 VDD VDD PMOS_VTL L=0.05U W=2.52U AS=0.19845P AD=0.1764P PS=3.78U
+ PD=3.08U
M$5 ZN A1 VDD VDD PMOS_VTL L=0.05U W=2.52U AS=0.1764P AD=0.19845P PS=3.08U
+ PD=3.78U
M$9 VSS A2 \$3 VSS NMOS_VTL L=0.05U W=1.66U AS=0.130725P AD=0.1162P PS=2.705U
+ PD=2.22U
M$13 ZN A1 \$3 VSS NMOS_VTL L=0.05U W=1.66U AS=0.1162P AD=0.130725P PS=2.22U
+ PD=2.705U
.ENDS NAND2_X4

.SUBCKT OAI21_X2 A B2 B1 VDD VSS ZN
M$1 ZN A VDD VDD PMOS_VTL L=0.05U W=1.26U AS=0.11025P AD=0.0882P PS=2.24U
+ PD=1.54U
M$3 \$10 B2 VDD VDD PMOS_VTL L=0.05U W=0.63U AS=0.0441P AD=0.0441P PS=0.77U
+ PD=0.77U
M$4 ZN B1 \$10 VDD PMOS_VTL L=0.05U W=0.63U AS=0.0441P AD=0.0441P PS=0.77U
+ PD=0.77U
M$5 \$11 B1 ZN VDD PMOS_VTL L=0.05U W=0.63U AS=0.0441P AD=0.0441P PS=0.77U
+ PD=0.77U
M$6 VDD B2 \$11 VDD PMOS_VTL L=0.05U W=0.63U AS=0.0441P AD=0.06615P PS=0.77U
+ PD=1.47U
M$7 VSS A \$4 VSS NMOS_VTL L=0.05U W=0.83U AS=0.072625P AD=0.0581P PS=1.595U
+ PD=1.11U
M$9 ZN B2 \$4 VSS NMOS_VTL L=0.05U W=0.83U AS=0.0581P AD=0.072625P PS=1.11U
+ PD=1.595U
M$10 \$4 B1 ZN VSS NMOS_VTL L=0.05U W=0.83U AS=0.0581P AD=0.0581P PS=1.11U
+ PD=1.11U
.ENDS OAI21_X2

.SUBCKT NAND3_X2 A3 A2 A1 VSS VDD ZN
M$1 ZN A3 VDD VDD PMOS_VTL L=0.05U W=1.26U AS=0.11025P AD=0.11025P PS=2.24U
+ PD=2.24U
M$2 VDD A2 ZN VDD PMOS_VTL L=0.05U W=1.26U AS=0.0882P AD=0.0882P PS=1.54U
+ PD=1.54U
M$3 ZN A1 VDD VDD PMOS_VTL L=0.05U W=1.26U AS=0.0882P AD=0.0882P PS=1.54U
+ PD=1.54U
M$7 \$12 A3 VSS VSS NMOS_VTL L=0.05U W=0.415U AS=0.043575P AD=0.02905P PS=1.04U
+ PD=0.555U
M$8 \$11 A2 \$12 VSS NMOS_VTL L=0.05U W=0.415U AS=0.02905P AD=0.02905P
+ PS=0.555U PD=0.555U
M$9 ZN A1 \$11 VSS NMOS_VTL L=0.05U W=0.415U AS=0.02905P AD=0.02905P PS=0.555U
+ PD=0.555U
M$10 \$10 A1 ZN VSS NMOS_VTL L=0.05U W=0.415U AS=0.02905P AD=0.02905P PS=0.555U
+ PD=0.555U
M$11 \$9 A2 \$10 VSS NMOS_VTL L=0.05U W=0.415U AS=0.02905P AD=0.02905P
+ PS=0.555U PD=0.555U
M$12 VSS A3 \$9 VSS NMOS_VTL L=0.05U W=0.415U AS=0.02905P AD=0.043575P
+ PS=0.555U PD=1.04U
.ENDS NAND3_X2

.SUBCKT NOR4_X1 A4 A3 A2 A1 VSS VDD ZN
M$1 \$12 A4 VDD VDD PMOS_VTL L=0.05U W=0.63U AS=0.06615P AD=0.0441P PS=1.47U
+ PD=0.77U
M$2 \$11 A3 \$12 VDD PMOS_VTL L=0.05U W=0.63U AS=0.0441P AD=0.0441P PS=0.77U
+ PD=0.77U
M$3 \$10 A2 \$11 VDD PMOS_VTL L=0.05U W=0.63U AS=0.0441P AD=0.0441P PS=0.77U
+ PD=0.77U
M$4 ZN A1 \$10 VDD PMOS_VTL L=0.05U W=0.63U AS=0.0441P AD=0.06615P PS=0.77U
+ PD=1.47U
M$5 ZN A4 VSS VSS NMOS_VTL L=0.05U W=0.415U AS=0.043575P AD=0.02905P PS=1.04U
+ PD=0.555U
M$6 VSS A3 ZN VSS NMOS_VTL L=0.05U W=0.415U AS=0.02905P AD=0.02905P PS=0.555U
+ PD=0.555U
M$7 ZN A2 VSS VSS NMOS_VTL L=0.05U W=0.415U AS=0.02905P AD=0.02905P PS=0.555U
+ PD=0.555U
M$8 VSS A1 ZN VSS NMOS_VTL L=0.05U W=0.415U AS=0.02905P AD=0.043575P PS=0.555U
+ PD=1.04U
.ENDS NOR4_X1

.SUBCKT NOR2_X2 A2 A1 VSS VDD ZN
M$1 \$9 A2 VDD VDD PMOS_VTL L=0.05U W=0.63U AS=0.06615P AD=0.0441P PS=1.47U
+ PD=0.77U
M$2 ZN A1 \$9 VDD PMOS_VTL L=0.05U W=0.63U AS=0.0441P AD=0.0441P PS=0.77U
+ PD=0.77U
M$3 \$8 A1 ZN VDD PMOS_VTL L=0.05U W=0.63U AS=0.0441P AD=0.0441P PS=0.77U
+ PD=0.77U
M$4 VDD A2 \$8 VDD PMOS_VTL L=0.05U W=0.63U AS=0.0441P AD=0.06615P PS=0.77U
+ PD=1.47U
M$5 ZN A2 VSS VSS NMOS_VTL L=0.05U W=0.83U AS=0.072625P AD=0.072625P PS=1.595U
+ PD=1.595U
M$6 VSS A1 ZN VSS NMOS_VTL L=0.05U W=0.83U AS=0.0581P AD=0.0581P PS=1.11U
+ PD=1.11U
.ENDS NOR2_X2

.SUBCKT OR2_X1 A1 A2 VSS VDD ZN
M$1 \$9 A1 \$4 VDD PMOS_VTL L=0.05U W=0.315U AS=0.033075P AD=0.02205P PS=0.84U
+ PD=0.455U
M$2 \$9 A2 VDD VDD PMOS_VTL L=0.05U W=0.315U AS=0.033075P AD=0.02205P PS=0.77U
+ PD=0.455U
M$3 ZN \$4 VDD VDD PMOS_VTL L=0.05U W=0.63U AS=0.033075P AD=0.06615P PS=0.77U
+ PD=1.47U
M$4 \$4 A1 VSS VSS NMOS_VTL L=0.05U W=0.21U AS=0.02205P AD=0.0147P PS=0.63U
+ PD=0.35U
M$5 VSS A2 \$4 VSS NMOS_VTL L=0.05U W=0.21U AS=0.0147P AD=0.021875P PS=0.35U
+ PD=0.555U
M$6 ZN \$4 VSS VSS NMOS_VTL L=0.05U W=0.415U AS=0.021875P AD=0.043575P
+ PS=0.555U PD=1.04U
.ENDS OR2_X1

.SUBCKT AND2_X1 A1 A2 VDD VSS ZN
M$1 \$3 A1 VDD VDD PMOS_VTL L=0.05U W=0.315U AS=0.033075P AD=0.02205P PS=0.84U
+ PD=0.455U
M$2 \$3 A2 VDD VDD PMOS_VTL L=0.05U W=0.315U AS=0.033075P AD=0.02205P PS=0.77U
+ PD=0.455U
M$3 ZN \$3 VDD VDD PMOS_VTL L=0.05U W=0.63U AS=0.033075P AD=0.06615P PS=0.77U
+ PD=1.47U
M$4 \$9 A1 \$3 VSS NMOS_VTL L=0.05U W=0.21U AS=0.02205P AD=0.0147P PS=0.63U
+ PD=0.35U
M$5 VSS A2 \$9 VSS NMOS_VTL L=0.05U W=0.21U AS=0.0147P AD=0.021875P PS=0.35U
+ PD=0.555U
M$6 ZN \$3 VSS VSS NMOS_VTL L=0.05U W=0.415U AS=0.021875P AD=0.043575P
+ PS=0.555U PD=1.04U
.ENDS AND2_X1

.SUBCKT NOR2_X4 A2 A1 ZN VSS VDD
M$1 \$11 A2 VDD VDD PMOS_VTL L=0.05U W=0.63U AS=0.06615P AD=0.0441P PS=1.47U
+ PD=0.77U
M$2 ZN A1 \$11 VDD PMOS_VTL L=0.05U W=0.63U AS=0.0441P AD=0.0441P PS=0.77U
+ PD=0.77U
M$3 \$10 A1 ZN VDD PMOS_VTL L=0.05U W=0.63U AS=0.0441P AD=0.0441P PS=0.77U
+ PD=0.77U
M$4 VDD A2 \$10 VDD PMOS_VTL L=0.05U W=0.63U AS=0.0441P AD=0.0441P PS=0.77U
+ PD=0.77U
M$5 \$9 A2 VDD VDD PMOS_VTL L=0.05U W=0.63U AS=0.0441P AD=0.0441P PS=0.77U
+ PD=0.77U
M$6 ZN A1 \$9 VDD PMOS_VTL L=0.05U W=0.63U AS=0.0441P AD=0.0441P PS=0.77U
+ PD=0.77U
M$7 \$8 A1 ZN VDD PMOS_VTL L=0.05U W=0.63U AS=0.0441P AD=0.0441P PS=0.77U
+ PD=0.77U
M$8 VDD A2 \$8 VDD PMOS_VTL L=0.05U W=0.63U AS=0.0441P AD=0.06615P PS=0.77U
+ PD=1.47U
M$9 ZN A2 VSS VSS NMOS_VTL L=0.05U W=1.66U AS=0.130725P AD=0.130725P PS=2.705U
+ PD=2.705U
M$10 VSS A1 ZN VSS NMOS_VTL L=0.05U W=1.66U AS=0.1162P AD=0.1162P PS=2.22U
+ PD=2.22U
.ENDS NOR2_X4

.SUBCKT OAI221_X1 B2 B1 A C2 C1 VDD VSS ZN
M$1 \$14 B2 VDD VDD PMOS_VTL L=0.05U W=0.63U AS=0.06615P AD=0.0441P PS=1.47U
+ PD=0.77U
M$2 ZN B1 \$14 VDD PMOS_VTL L=0.05U W=0.63U AS=0.0441P AD=0.0441P PS=0.77U
+ PD=0.77U
M$3 VDD A ZN VDD PMOS_VTL L=0.05U W=0.63U AS=0.0441P AD=0.0441P PS=0.77U
+ PD=0.77U
M$4 \$13 C2 VDD VDD PMOS_VTL L=0.05U W=0.63U AS=0.0441P AD=0.0441P PS=0.77U
+ PD=0.77U
M$5 ZN C1 \$13 VDD PMOS_VTL L=0.05U W=0.63U AS=0.0441P AD=0.06615P PS=0.77U
+ PD=1.47U
M$6 VSS B2 \$6 VSS NMOS_VTL L=0.05U W=0.415U AS=0.043575P AD=0.02905P PS=1.04U
+ PD=0.555U
M$7 \$6 B1 VSS VSS NMOS_VTL L=0.05U W=0.415U AS=0.02905P AD=0.02905P PS=0.555U
+ PD=0.555U
M$8 \$10 A \$6 VSS NMOS_VTL L=0.05U W=0.415U AS=0.02905P AD=0.02905P PS=0.555U
+ PD=0.555U
M$9 ZN C2 \$10 VSS NMOS_VTL L=0.05U W=0.415U AS=0.02905P AD=0.02905P PS=0.555U
+ PD=0.555U
M$10 \$10 C1 ZN VSS NMOS_VTL L=0.05U W=0.415U AS=0.02905P AD=0.043575P
+ PS=0.555U PD=1.04U
.ENDS OAI221_X1

.SUBCKT INV_X4 A VSS VDD ZN
M$1 ZN A VDD VDD PMOS_VTL L=0.05U W=2.52U AS=0.19845P AD=0.19845P PS=3.78U
+ PD=3.78U
M$5 ZN A VSS VSS NMOS_VTL L=0.05U W=1.66U AS=0.130725P AD=0.130725P PS=2.705U
+ PD=2.705U
.ENDS INV_X4

.SUBCKT BUF_X1 A VSS VDD Z
M$1 \$2 A VDD VDD PMOS_VTL L=0.05U W=0.315U AS=0.033075P AD=0.033075P PS=0.77U
+ PD=0.84U
M$2 Z \$2 VDD VDD PMOS_VTL L=0.05U W=0.63U AS=0.033075P AD=0.06615P PS=0.77U
+ PD=1.47U
M$3 VSS A \$2 VSS NMOS_VTL L=0.05U W=0.21U AS=0.02205P AD=0.021875P PS=0.63U
+ PD=0.555U
M$4 Z \$2 VSS VSS NMOS_VTL L=0.05U W=0.415U AS=0.021875P AD=0.043575P PS=0.555U
+ PD=1.04U
.ENDS BUF_X1

.SUBCKT CLKBUF_X1 A VSS VDD
M$1 \$2 A VDD VDD PMOS_VTL L=0.05U W=0.315U AS=0.033075P AD=0.033075P PS=0.77U
+ PD=0.84U
M$2 Z \$2 VDD VDD PMOS_VTL L=0.05U W=0.63U AS=0.033075P AD=0.06615P PS=0.77U
+ PD=1.47U
M$3 VSS A \$2 VSS NMOS_VTL L=0.05U W=0.095U AS=0.009975P AD=0.01015P PS=0.4U
+ PD=0.335U
M$4 Z \$2 VSS VSS NMOS_VTL L=0.05U W=0.195U AS=0.01015P AD=0.020475P PS=0.335U
+ PD=0.6U
.ENDS CLKBUF_X1

.SUBCKT CLKBUF_X3 A VSS VDD Z
M$1 VDD A \$2 VDD PMOS_VTL L=0.05U W=0.63U AS=0.06615P AD=0.0441P PS=1.47U
+ PD=0.77U
M$2 Z \$2 VDD VDD PMOS_VTL L=0.05U W=1.89U AS=0.1323P AD=0.15435P PS=2.31U
+ PD=3.01U
M$5 VSS A \$2 VSS NMOS_VTL L=0.05U W=0.195U AS=0.020475P AD=0.01365P PS=0.6U
+ PD=0.335U
M$6 Z \$2 VSS VSS NMOS_VTL L=0.05U W=0.585U AS=0.04095P AD=0.047775P PS=1.005U
+ PD=1.27U
.ENDS CLKBUF_X3

.SUBCKT DFFR_X1 VSS CK QN Q D RN VDD
M$1 VDD \$6 QN VDD PMOS_VTL L=0.05U W=0.63U AS=0.06615P AD=0.0441P PS=1.47U
+ PD=0.77U
M$2 Q \$7 VDD VDD PMOS_VTL L=0.05U W=0.63U AS=0.0441P AD=0.06615P PS=0.77U
+ PD=1.47U
M$3 \$22 \$4 \$6 VDD PMOS_VTL L=0.05U W=0.09U AS=0.014175P AD=0.0063P PS=0.455U
+ PD=0.23U
M$4 VDD \$7 \$22 VDD PMOS_VTL L=0.05U W=0.09U AS=0.0063P AD=0.014175P PS=0.23U
+ PD=0.455U
M$5 VDD \$5 \$18 VDD PMOS_VTL L=0.05U W=0.315U AS=0.03465P AD=0.033075P
+ PS=0.85U PD=0.525U
M$6 \$24 \$5 VDD VDD PMOS_VTL L=0.05U W=0.315U AS=0.033075P AD=0.02205P
+ PS=0.525U PD=0.455U
M$7 \$6 \$2 \$24 VDD PMOS_VTL L=0.05U W=0.315U AS=0.02205P AD=0.014175P
+ PS=0.455U PD=0.455U
M$8 \$7 RN VDD VDD PMOS_VTL L=0.05U W=0.315U AS=0.014175P AD=0.02205P PS=0.455U
+ PD=0.455U
M$9 VDD \$6 \$7 VDD PMOS_VTL L=0.05U W=0.315U AS=0.02205P AD=0.033075P
+ PS=0.455U PD=0.84U
M$10 \$21 \$2 \$5 VDD PMOS_VTL L=0.05U W=0.09U AS=0.01785P AD=0.0063P PS=0.56U
+ PD=0.23U
M$11 VDD \$18 \$21 VDD PMOS_VTL L=0.05U W=0.09U AS=0.0063P AD=0.0063P PS=0.23U
+ PD=0.23U
M$12 \$21 RN VDD VDD PMOS_VTL L=0.05U W=0.09U AS=0.0063P AD=0.01035P PS=0.23U
+ PD=0.41U
M$13 \$23 D VDD VDD PMOS_VTL L=0.05U W=0.42U AS=0.0441P AD=0.0294P PS=1.05U
+ PD=0.56U
M$14 \$5 \$4 \$23 VDD PMOS_VTL L=0.05U W=0.42U AS=0.0294P AD=0.01785P PS=0.56U
+ PD=0.56U
M$15 VDD CK \$2 VDD PMOS_VTL L=0.05U W=0.315U AS=0.033075P AD=0.02205P PS=0.84U
+ PD=0.455U
M$16 \$4 \$2 VDD VDD PMOS_VTL L=0.05U W=0.315U AS=0.02205P AD=0.033075P
+ PS=0.455U PD=0.84U
M$17 VSS \$6 QN VSS NMOS_VTL L=0.05U W=0.415U AS=0.043575P AD=0.02905P PS=1.04U
+ PD=0.555U
M$18 Q \$7 VSS VSS NMOS_VTL L=0.05U W=0.415U AS=0.02905P AD=0.043575P PS=0.555U
+ PD=1.04U
M$19 \$13 \$4 \$5 VSS NMOS_VTL L=0.05U W=0.09U AS=0.012775P AD=0.0063P
+ PS=0.415U PD=0.23U
M$20 \$12 \$18 \$13 VSS NMOS_VTL L=0.05U W=0.09U AS=0.0063P AD=0.0063P PS=0.23U
+ PD=0.23U
M$21 VSS RN \$12 VSS NMOS_VTL L=0.05U W=0.09U AS=0.0063P AD=0.00945P PS=0.23U
+ PD=0.39U
M$22 \$11 D VSS VSS NMOS_VTL L=0.05U W=0.275U AS=0.028875P AD=0.01925P PS=0.76U
+ PD=0.415U
M$23 \$5 \$2 \$11 VSS NMOS_VTL L=0.05U W=0.275U AS=0.01925P AD=0.012775P
+ PS=0.415U PD=0.415U
M$24 \$16 \$2 \$6 VSS NMOS_VTL L=0.05U W=0.09U AS=0.0105P AD=0.0063P PS=0.35U
+ PD=0.23U
M$25 VSS \$7 \$16 VSS NMOS_VTL L=0.05U W=0.09U AS=0.0063P AD=0.0105P PS=0.23U
+ PD=0.35U
M$26 VSS \$5 \$18 VSS NMOS_VTL L=0.05U W=0.21U AS=0.02205P AD=0.02205P PS=0.63U
+ PD=0.42U
M$27 \$15 \$5 VSS VSS NMOS_VTL L=0.05U W=0.21U AS=0.02205P AD=0.0147P PS=0.42U
+ PD=0.35U
M$28 \$6 \$4 \$15 VSS NMOS_VTL L=0.05U W=0.21U AS=0.0147P AD=0.0105P PS=0.35U
+ PD=0.35U
M$29 \$14 RN VSS VSS NMOS_VTL L=0.05U W=0.21U AS=0.0105P AD=0.0147P PS=0.35U
+ PD=0.35U
M$30 \$7 \$6 \$14 VSS NMOS_VTL L=0.05U W=0.21U AS=0.0147P AD=0.02205P PS=0.35U
+ PD=0.63U
M$31 VSS CK \$2 VSS NMOS_VTL L=0.05U W=0.21U AS=0.02205P AD=0.0147P PS=0.63U
+ PD=0.35U
M$32 \$4 \$2 VSS VSS NMOS_VTL L=0.05U W=0.21U AS=0.0147P AD=0.02205P PS=0.35U
+ PD=0.63U
.ENDS DFFR_X1

.SUBCKT HA_X1 A B S VDD VSS CO
M$1 \$12 B VDD VDD PMOS_VTL L=0.05U W=0.315U AS=0.0338625P AD=0.02205P
+ PS=0.775U PD=0.455U
M$2 \$7 A \$12 VDD PMOS_VTL L=0.05U W=0.315U AS=0.02205P AD=0.033075P PS=0.455U
+ PD=0.84U
M$3 S B \$3 VDD PMOS_VTL L=0.05U W=0.63U AS=0.06615P AD=0.0441P PS=1.47U
+ PD=0.77U
M$4 \$3 A S VDD PMOS_VTL L=0.05U W=0.63U AS=0.0441P AD=0.0441P PS=0.77U PD=0.77U
M$5 VDD \$7 \$3 VDD PMOS_VTL L=0.05U W=0.63U AS=0.0441P AD=0.0338625P PS=0.77U
+ PD=0.775U
M$6 \$8 A VDD VDD PMOS_VTL L=0.05U W=0.315U AS=0.033075P AD=0.02205P PS=0.84U
+ PD=0.455U
M$7 \$8 B VDD VDD PMOS_VTL L=0.05U W=0.315U AS=0.033075P AD=0.02205P PS=0.77U
+ PD=0.455U
M$8 CO \$8 VDD VDD PMOS_VTL L=0.05U W=0.63U AS=0.033075P AD=0.06615P PS=0.77U
+ PD=1.47U
M$9 \$7 B VSS VSS NMOS_VTL L=0.05U W=0.21U AS=0.0224P AD=0.0147P PS=0.56U
+ PD=0.35U
M$10 VSS A \$7 VSS NMOS_VTL L=0.05U W=0.21U AS=0.0147P AD=0.02205P PS=0.35U
+ PD=0.63U
M$11 \$13 B VSS VSS NMOS_VTL L=0.05U W=0.415U AS=0.043575P AD=0.02905P PS=1.04U
+ PD=0.555U
M$12 S A \$13 VSS NMOS_VTL L=0.05U W=0.415U AS=0.02905P AD=0.02905P PS=0.555U
+ PD=0.555U
M$13 VSS \$7 S VSS NMOS_VTL L=0.05U W=0.415U AS=0.02905P AD=0.0224P PS=0.555U
+ PD=0.56U
M$14 \$14 A \$8 VSS NMOS_VTL L=0.05U W=0.21U AS=0.02205P AD=0.0147P PS=0.63U
+ PD=0.35U
M$15 VSS B \$14 VSS NMOS_VTL L=0.05U W=0.21U AS=0.0147P AD=0.021875P PS=0.35U
+ PD=0.555U
M$16 CO \$8 VSS VSS NMOS_VTL L=0.05U W=0.415U AS=0.021875P AD=0.043575P
+ PS=0.555U PD=1.04U
.ENDS HA_X1

.SUBCKT FA_X1 VSS B CO S CI A VDD
M$1 \$18 B VDD VDD PMOS_VTL L=0.05U W=0.315U AS=0.033075P AD=0.02205P PS=0.77U
+ PD=0.455U
M$2 \$4 A \$18 VDD PMOS_VTL L=0.05U W=0.315U AS=0.02205P AD=0.02205P PS=0.455U
+ PD=0.455U
M$3 \$16 CI \$4 VDD PMOS_VTL L=0.05U W=0.315U AS=0.02205P AD=0.02265P PS=0.455U
+ PD=0.535U
M$4 VDD A \$16 VDD PMOS_VTL L=0.05U W=0.315U AS=0.02265P AD=0.02205P PS=0.535U
+ PD=0.455U
M$5 \$16 B VDD VDD PMOS_VTL L=0.05U W=0.315U AS=0.02205P AD=0.033075P PS=0.455U
+ PD=0.84U
M$6 VDD \$4 CO VDD PMOS_VTL L=0.05U W=0.63U AS=0.06615P AD=0.033075P PS=1.47U
+ PD=0.77U
M$7 \$17 B VDD VDD PMOS_VTL L=0.05U W=0.315U AS=0.033075P AD=0.02205P PS=0.84U
+ PD=0.455U
M$8 VDD CI \$17 VDD PMOS_VTL L=0.05U W=0.315U AS=0.02205P AD=0.02205P PS=0.455U
+ PD=0.455U
M$9 \$17 A VDD VDD PMOS_VTL L=0.05U W=0.315U AS=0.02205P AD=0.02205P PS=0.455U
+ PD=0.455U
M$10 \$7 \$4 \$17 VDD PMOS_VTL L=0.05U W=0.315U AS=0.02205P AD=0.023625P
+ PS=0.455U PD=0.465U
M$11 \$19 CI \$7 VDD PMOS_VTL L=0.05U W=0.315U AS=0.023625P AD=0.02205P
+ PS=0.465U PD=0.455U
M$12 \$20 B \$19 VDD PMOS_VTL L=0.05U W=0.315U AS=0.02205P AD=0.02205P
+ PS=0.455U PD=0.455U
M$13 \$20 A VDD VDD PMOS_VTL L=0.05U W=0.315U AS=0.033075P AD=0.02205P PS=0.77U
+ PD=0.455U
M$14 S \$7 VDD VDD PMOS_VTL L=0.05U W=0.63U AS=0.033075P AD=0.06615P PS=0.77U
+ PD=1.47U
M$15 \$6 B VSS VSS NMOS_VTL L=0.05U W=0.21U AS=0.02205P AD=0.0147P PS=0.63U
+ PD=0.35U
M$16 VSS CI \$6 VSS NMOS_VTL L=0.05U W=0.21U AS=0.0147P AD=0.0147P PS=0.35U
+ PD=0.35U
M$17 \$6 A VSS VSS NMOS_VTL L=0.05U W=0.21U AS=0.0147P AD=0.0147P PS=0.35U
+ PD=0.35U
M$18 \$7 \$4 \$6 VSS NMOS_VTL L=0.05U W=0.21U AS=0.0147P AD=0.01575P PS=0.35U
+ PD=0.36U
M$19 \$9 CI \$7 VSS NMOS_VTL L=0.05U W=0.21U AS=0.01575P AD=0.0147P PS=0.36U
+ PD=0.35U
M$20 \$10 B \$9 VSS NMOS_VTL L=0.05U W=0.21U AS=0.0147P AD=0.0147P PS=0.35U
+ PD=0.35U
M$21 VSS A \$10 VSS NMOS_VTL L=0.05U W=0.21U AS=0.0147P AD=0.021875P PS=0.35U
+ PD=0.555U
M$22 S \$7 VSS VSS NMOS_VTL L=0.05U W=0.415U AS=0.021875P AD=0.043575P
+ PS=0.555U PD=1.04U
M$23 \$14 B VSS VSS NMOS_VTL L=0.05U W=0.21U AS=0.021875P AD=0.0147P PS=0.555U
+ PD=0.35U
M$24 \$4 A \$14 VSS NMOS_VTL L=0.05U W=0.21U AS=0.0147P AD=0.0147P PS=0.35U
+ PD=0.35U
M$25 \$5 CI \$4 VSS NMOS_VTL L=0.05U W=0.21U AS=0.0147P AD=0.015225P PS=0.35U
+ PD=0.355U
M$26 VSS A \$5 VSS NMOS_VTL L=0.05U W=0.21U AS=0.015225P AD=0.0147P PS=0.355U
+ PD=0.35U
M$27 \$5 B VSS VSS NMOS_VTL L=0.05U W=0.21U AS=0.0147P AD=0.02205P PS=0.35U
+ PD=0.63U
M$28 VSS \$4 CO VSS NMOS_VTL L=0.05U W=0.415U AS=0.043575P AD=0.021875P
+ PS=1.04U PD=0.555U
.ENDS FA_X1

.SUBCKT XOR2_X1 A B VSS VDD Z
M$1 \$10 A \$2 VDD PMOS_VTL L=0.05U W=0.315U AS=0.033075P AD=0.02205P PS=0.84U
+ PD=0.455U
M$2 \$10 B VDD VDD PMOS_VTL L=0.05U W=0.315U AS=0.0338625P AD=0.02205P
+ PS=0.775U PD=0.455U
M$3 \$7 \$2 VDD VDD PMOS_VTL L=0.05U W=0.63U AS=0.0338625P AD=0.0441P PS=0.775U
+ PD=0.77U
M$4 Z A \$7 VDD PMOS_VTL L=0.05U W=0.63U AS=0.0441P AD=0.0441P PS=0.77U PD=0.77U
M$5 \$7 B Z VDD PMOS_VTL L=0.05U W=0.63U AS=0.0441P AD=0.06615P PS=0.77U
+ PD=1.47U
M$6 \$2 A VSS VSS NMOS_VTL L=0.05U W=0.21U AS=0.02205P AD=0.0147P PS=0.63U
+ PD=0.35U
M$7 VSS B \$2 VSS NMOS_VTL L=0.05U W=0.21U AS=0.0147P AD=0.0224P PS=0.35U
+ PD=0.56U
M$8 Z \$2 VSS VSS NMOS_VTL L=0.05U W=0.415U AS=0.0224P AD=0.02905P PS=0.56U
+ PD=0.555U
M$9 \$11 A Z VSS NMOS_VTL L=0.05U W=0.415U AS=0.02905P AD=0.02905P PS=0.555U
+ PD=0.555U
M$10 VSS B \$11 VSS NMOS_VTL L=0.05U W=0.415U AS=0.02905P AD=0.043575P
+ PS=0.555U PD=1.04U
.ENDS XOR2_X1

.SUBCKT AOI21_X1 A B2 B1 VSS ZN VDD
M$1 ZN B2 \$5 VDD PMOS_VTL L=0.05U W=0.63U AS=0.06615P AD=0.0441P PS=1.47U
+ PD=0.77U
M$2 \$5 B1 ZN VDD PMOS_VTL L=0.05U W=0.63U AS=0.0441P AD=0.0441P PS=0.77U
+ PD=0.77U
M$3 VDD A \$5 VDD PMOS_VTL L=0.05U W=0.63U AS=0.0441P AD=0.06615P PS=0.77U
+ PD=1.47U
M$4 \$10 B2 VSS VSS NMOS_VTL L=0.05U W=0.415U AS=0.043575P AD=0.02905P PS=1.04U
+ PD=0.555U
M$5 ZN B1 \$10 VSS NMOS_VTL L=0.05U W=0.415U AS=0.02905P AD=0.02905P PS=0.555U
+ PD=0.555U
M$6 VSS A ZN VSS NMOS_VTL L=0.05U W=0.415U AS=0.02905P AD=0.043575P PS=0.555U
+ PD=1.04U
.ENDS AOI21_X1

.SUBCKT INV_X2 A VSS VDD ZN
M$1 ZN A VDD VDD PMOS_VTL L=0.05U W=1.26U AS=0.11025P AD=0.11025P PS=2.24U
+ PD=2.24U
M$3 ZN A VSS VSS NMOS_VTL L=0.05U W=0.83U AS=0.072625P AD=0.072625P PS=1.595U
+ PD=1.595U
.ENDS INV_X2

.SUBCKT NOR3_X1 A3 A2 A1 VSS VDD ZN
M$1 \$10 A3 VDD VDD PMOS_VTL L=0.05U W=0.63U AS=0.06615P AD=0.0441P PS=1.47U
+ PD=0.77U
M$2 \$9 A2 \$10 VDD PMOS_VTL L=0.05U W=0.63U AS=0.0441P AD=0.0441P PS=0.77U
+ PD=0.77U
M$3 ZN A1 \$9 VDD PMOS_VTL L=0.05U W=0.63U AS=0.0441P AD=0.06615P PS=0.77U
+ PD=1.47U
M$4 ZN A3 VSS VSS NMOS_VTL L=0.05U W=0.415U AS=0.043575P AD=0.02905P PS=1.04U
+ PD=0.555U
M$5 VSS A2 ZN VSS NMOS_VTL L=0.05U W=0.415U AS=0.02905P AD=0.02905P PS=0.555U
+ PD=0.555U
M$6 ZN A1 VSS VSS NMOS_VTL L=0.05U W=0.415U AS=0.02905P AD=0.043575P PS=0.555U
+ PD=1.04U
.ENDS NOR3_X1

.SUBCKT XNOR2_X1 A B VDD VSS ZN
M$1 \$3 A VDD VDD PMOS_VTL L=0.05U W=0.315U AS=0.033075P AD=0.02205P PS=0.84U
+ PD=0.455U
M$2 \$3 B VDD VDD PMOS_VTL L=0.05U W=0.315U AS=0.0338625P AD=0.02205P PS=0.775U
+ PD=0.455U
M$3 ZN \$3 VDD VDD PMOS_VTL L=0.05U W=0.63U AS=0.0338625P AD=0.0441P PS=0.775U
+ PD=0.77U
M$4 \$10 A ZN VDD PMOS_VTL L=0.05U W=0.63U AS=0.0441P AD=0.0441P PS=0.77U
+ PD=0.77U
M$5 VDD B \$10 VDD PMOS_VTL L=0.05U W=0.63U AS=0.0441P AD=0.06615P PS=0.77U
+ PD=1.47U
M$6 \$11 A \$3 VSS NMOS_VTL L=0.05U W=0.21U AS=0.02205P AD=0.0147P PS=0.63U
+ PD=0.35U
M$7 VSS B \$11 VSS NMOS_VTL L=0.05U W=0.21U AS=0.0147P AD=0.0224P PS=0.35U
+ PD=0.56U
M$8 \$6 \$3 VSS VSS NMOS_VTL L=0.05U W=0.415U AS=0.0224P AD=0.02905P PS=0.56U
+ PD=0.555U
M$9 ZN A \$6 VSS NMOS_VTL L=0.05U W=0.415U AS=0.02905P AD=0.02905P PS=0.555U
+ PD=0.555U
M$10 \$6 B ZN VSS NMOS_VTL L=0.05U W=0.415U AS=0.02905P AD=0.043575P PS=0.555U
+ PD=1.04U
.ENDS XNOR2_X1

.SUBCKT NAND3_X1 A3 A2 A1 VSS VDD ZN
M$1 ZN A3 VDD VDD PMOS_VTL L=0.05U W=0.63U AS=0.06615P AD=0.0441P PS=1.47U
+ PD=0.77U
M$2 VDD A2 ZN VDD PMOS_VTL L=0.05U W=0.63U AS=0.0441P AD=0.0441P PS=0.77U
+ PD=0.77U
M$3 ZN A1 VDD VDD PMOS_VTL L=0.05U W=0.63U AS=0.0441P AD=0.06615P PS=0.77U
+ PD=1.47U
M$4 \$10 A3 VSS VSS NMOS_VTL L=0.05U W=0.415U AS=0.043575P AD=0.02905P PS=1.04U
+ PD=0.555U
M$5 \$9 A2 \$10 VSS NMOS_VTL L=0.05U W=0.415U AS=0.02905P AD=0.02905P PS=0.555U
+ PD=0.555U
M$6 ZN A1 \$9 VSS NMOS_VTL L=0.05U W=0.415U AS=0.02905P AD=0.043575P PS=0.555U
+ PD=1.04U
.ENDS NAND3_X1

.SUBCKT NAND4_X1 A4 A3 A2 A1 VSS VDD ZN
M$1 ZN A4 VDD VDD PMOS_VTL L=0.05U W=0.63U AS=0.06615P AD=0.0441P PS=1.47U
+ PD=0.77U
M$2 VDD A3 ZN VDD PMOS_VTL L=0.05U W=0.63U AS=0.0441P AD=0.0441P PS=0.77U
+ PD=0.77U
M$3 ZN A2 VDD VDD PMOS_VTL L=0.05U W=0.63U AS=0.0441P AD=0.0441P PS=0.77U
+ PD=0.77U
M$4 VDD A1 ZN VDD PMOS_VTL L=0.05U W=0.63U AS=0.0441P AD=0.06615P PS=0.77U
+ PD=1.47U
M$5 \$12 A4 VSS VSS NMOS_VTL L=0.05U W=0.415U AS=0.043575P AD=0.02905P PS=1.04U
+ PD=0.555U
M$6 \$11 A3 \$12 VSS NMOS_VTL L=0.05U W=0.415U AS=0.02905P AD=0.02905P
+ PS=0.555U PD=0.555U
M$7 \$10 A2 \$11 VSS NMOS_VTL L=0.05U W=0.415U AS=0.02905P AD=0.02905P
+ PS=0.555U PD=0.555U
M$8 ZN A1 \$10 VSS NMOS_VTL L=0.05U W=0.415U AS=0.02905P AD=0.043575P PS=0.555U
+ PD=1.04U
.ENDS NAND4_X1

.SUBCKT OAI21_X1 B2 B1 A VDD ZN VSS
M$1 \$10 B2 VDD VDD PMOS_VTL L=0.05U W=0.63U AS=0.06615P AD=0.0441P PS=1.47U
+ PD=0.77U
M$2 ZN B1 \$10 VDD PMOS_VTL L=0.05U W=0.63U AS=0.0441P AD=0.0441P PS=0.77U
+ PD=0.77U
M$3 VDD A ZN VDD PMOS_VTL L=0.05U W=0.63U AS=0.0441P AD=0.06615P PS=0.77U
+ PD=1.47U
M$4 ZN B2 \$4 VSS NMOS_VTL L=0.05U W=0.415U AS=0.043575P AD=0.02905P PS=1.04U
+ PD=0.555U
M$5 \$4 B1 ZN VSS NMOS_VTL L=0.05U W=0.415U AS=0.02905P AD=0.02905P PS=0.555U
+ PD=0.555U
M$6 VSS A \$4 VSS NMOS_VTL L=0.05U W=0.415U AS=0.02905P AD=0.043575P PS=0.555U
+ PD=1.04U
.ENDS OAI21_X1

.SUBCKT NOR2_X1 A2 A1 VSS VDD ZN
M$1 \$8 A2 VDD VDD PMOS_VTL L=0.05U W=0.63U AS=0.06615P AD=0.0441P PS=1.47U
+ PD=0.77U
M$2 ZN A1 \$8 VDD PMOS_VTL L=0.05U W=0.63U AS=0.0441P AD=0.06615P PS=0.77U
+ PD=1.47U
M$3 ZN A2 VSS VSS NMOS_VTL L=0.05U W=0.415U AS=0.043575P AD=0.02905P PS=1.04U
+ PD=0.555U
M$4 VSS A1 ZN VSS NMOS_VTL L=0.05U W=0.415U AS=0.02905P AD=0.043575P PS=0.555U
+ PD=1.04U
.ENDS NOR2_X1

.SUBCKT INV_X1 A VSS VDD ZN
M$1 ZN A VDD VDD PMOS_VTL L=0.05U W=0.63U AS=0.06615P AD=0.06615P PS=1.47U
+ PD=1.47U
M$2 ZN A VSS VSS NMOS_VTL L=0.05U W=0.415U AS=0.043575P AD=0.043575P PS=1.04U
+ PD=1.04U
.ENDS INV_X1

.SUBCKT NAND2_X1 A2 A1 VSS VDD ZN
M$1 ZN A2 VDD VDD PMOS_VTL L=0.05U W=0.63U AS=0.06615P AD=0.0441P PS=1.47U
+ PD=0.77U
M$2 VDD A1 ZN VDD PMOS_VTL L=0.05U W=0.63U AS=0.0441P AD=0.06615P PS=0.77U
+ PD=1.47U
M$3 \$8 A2 VSS VSS NMOS_VTL L=0.05U W=0.415U AS=0.043575P AD=0.02905P PS=1.04U
+ PD=0.555U
M$4 ZN A1 \$8 VSS NMOS_VTL L=0.05U W=0.415U AS=0.02905P AD=0.043575P PS=0.555U
+ PD=1.04U
.ENDS NAND2_X1
